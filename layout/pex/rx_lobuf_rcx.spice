* rx_lobuf: magic R+C extraction of layout/rx_lobuf.gds (layout/gen/pex.sh)
* rcfix.py: split-net C to VSS scaled by (S - K) / S on 5 nets (coupling double count removed)
* extracted 2026-11-15T23:47:46+01:00 with magic 8.3.642, mode rc, from rx_lobuf.gds
.subckt rx_lobuf VDD VSS in en lo lob
X0 t x VDD.t48 VDD.t47 pfet_03v3 ad=1.05p pd=4.1u as=1.05p ps=4.1u w=1.05u l=0.28u
X1 lob.t1 Ny2 VSS.t14 VSS.t13 nfet_03v3 ad=1.25p pd=3.5u as=2.5p ps=7u w=2.5u l=0.28u
X2 Ny2 Ny1 VDD.t40 VDD.t39 pfet_03v3 ad=1.25p pd=3.5u as=2.5p ps=7u w=2.5u l=0.28u
X3 a b VDD.t7 VDD.t6 pfet_03v3 ad=1.05p pd=4.1u as=1.05p ps=4.1u w=1.05u l=0.28u
X4 VSS.t10 Py2 lo.t3 VSS.t9 nfet_03v3 ad=2.5p pd=7u as=1.25p ps=3.5u w=2.5u l=0.28u
X5 VDD.t24 Ny0 Ny1 VDD.t23 pfet_03v3 ad=2p pd=6u as=2p ps=6u w=2u l=0.28u
X6 Py0 a VDD.t46 VDD.t45 pfet_03v3 ad=0.625p pd=2.25u as=1.25p ps=4.5u w=1.25u l=0.28u
X7 VDD.t5 b Ny0 VDD.t4 pfet_03v3 ad=1.25p pd=4.5u as=0.625p ps=2.25u w=1.25u l=0.28u
X8 tb t VDD.t3 VDD.t2 pfet_03v3 ad=3.75p pd=9.5u as=3.75p ps=9.5u w=3.75u l=0.28u
X9 a ta VSS.t12 VSS.t11 nfet_03v3 ad=1p pd=4u as=1p ps=4u w=1u l=0.28u
X10 b VSS.t38 tb VDD.t22 pfet_03v3 ad=2.5p pd=7u as=2.5p ps=7u w=2.5u l=0.28u
X11 x in.t1 VDD.t38 VDD.t37 pfet_03v3 ad=0.3p pd=1.6u as=0.6p ps=3.2u w=0.6u l=0.28u
X12 lo.t1 Py2 VDD.t13 VDD.t12 pfet_03v3 ad=4.165p pd=10.33u as=2.0825p ps=5.165u w=4.165u l=0.28u
X13 b VDD.t49 tb VSS.t37 nfet_03v3 ad=1p pd=4u as=1p ps=4u w=1u l=0.28u
X14 VDD.t34 en.t3 Py0 VDD.t33 pfet_03v3 ad=1.25p pd=4.5u as=0.625p ps=2.25u w=1.25u l=0.28u
X15 a b VSS.t6 VSS.t5 nfet_03v3 ad=0.42p pd=2.84u as=0.42p ps=2.84u w=0.42u l=0.28u
X16 b a VSS.t33 VSS.t32 nfet_03v3 ad=0.42p pd=2.84u as=0.42p ps=2.84u w=0.42u l=0.28u
X17 Py2 Py1 VDD.t26 VDD.t25 pfet_03v3 ad=1.25p pd=3.5u as=2.5p ps=7u w=2.5u l=0.28u
X18 VDD.t11 Py2 lo.t0 VDD.t10 pfet_03v3 ad=2.0825p pd=5.165u as=2.0825p ps=5.165u w=4.165u l=0.28u
X19 Py2 Py1 VSS.t20 VSS.t19 nfet_03v3 ad=2p pd=6u as=2p ps=6u w=2u l=0.28u
X20 Py1 Py0 VDD.t30 VDD.t29 pfet_03v3 ad=2p pd=6u as=2p ps=6u w=2u l=0.28u
X21 VSS.t16 Ny2 lob.t3 VSS.t15 nfet_03v3 ad=2.5p pd=7u as=1.25p ps=3.5u w=2.5u l=0.28u
X22 VSS.t28 en.t0 Pgs VSS.t27 nfet_03v3 ad=1p pd=4u as=0.28p ps=1.56u w=1u l=0.28u
X23 Ny0 b Ngs VSS.t4 nfet_03v3 ad=1p pd=4u as=0.28p ps=1.56u w=1u l=0.28u
X24 VSS.t26 en.t1 g0s VSS.t25 nfet_03v3 ad=0.5p pd=3u as=0.14p ps=1.06u w=0.5u l=0.28u
X25 tb t VSS.t3 VSS.t2 nfet_03v3 ad=1.5p pd=5u as=1.5p ps=5u w=1.5u l=0.28u
X26 Py1 Py0 VSS.t22 VSS.t21 nfet_03v3 ad=0.8p pd=3.6u as=0.8p ps=3.6u w=0.8u l=0.28u
X27 t x VSS.t36 VSS.t35 nfet_03v3 ad=0.42p pd=2.84u as=0.42p ps=2.84u w=0.42u l=0.28u
X28 VDD.t17 Ny2 lob.t4 VDD.t16 pfet_03v3 ad=2.0825p pd=5.165u as=4.165p ps=10.33u w=4.165u l=0.28u
X29 VDD.t21 Ny2 lob.t0 VDD.t20 pfet_03v3 ad=4.165p pd=10.33u as=2.0825p ps=5.165u w=4.165u l=0.28u
X30 Ny0 en.t5 VDD.t32 VDD.t31 pfet_03v3 ad=0.625p pd=2.25u as=1.25p ps=4.5u w=1.25u l=0.28u
X31 VSS.t31 Ny1 Ny2 VSS.t30 nfet_03v3 ad=2p pd=6u as=2p ps=6u w=2u l=0.28u
X32 Pgs a Py0 VSS.t34 nfet_03v3 ad=0.28p pd=1.56u as=1p ps=4u w=1u l=0.28u
X33 VDD.t36 en.t4 x VDD.t35 pfet_03v3 ad=0.6p pd=3.2u as=0.3p ps=1.6u w=0.6u l=0.28u
X34 VSS.t18 Ny0 Ny1 VSS.t17 nfet_03v3 ad=0.8p pd=3.6u as=0.8p ps=3.6u w=0.8u l=0.28u
X35 ta t VDD.t1 VDD.t0 pfet_03v3 ad=1.25p pd=4.5u as=1.25p ps=4.5u w=1.25u l=0.28u
X36 a ta VDD.t15 VDD.t14 pfet_03v3 ad=2.5p pd=7u as=2.5p ps=7u w=2.5u l=0.28u
X37 VDD.t42 Ny1 Ny2 VDD.t41 pfet_03v3 ad=2.5p pd=7u as=1.25p ps=3.5u w=2.5u l=0.28u
X38 b a VDD.t44 VDD.t43 pfet_03v3 ad=1.05p pd=4.1u as=1.05p ps=4.1u w=1.05u l=0.28u
X39 lob.t2 Ny2 VDD.t19 VDD.t18 pfet_03v3 ad=2.0825p pd=5.165u as=2.0825p ps=5.165u w=4.165u l=0.28u
X40 VDD.t28 Py1 Py2 VDD.t27 pfet_03v3 ad=2.5p pd=7u as=1.25p ps=3.5u w=2.5u l=0.28u
X41 ta t VSS.t1 VSS.t0 nfet_03v3 ad=0.5p pd=3u as=0.5p ps=3u w=0.5u l=0.28u
X42 lo.t2 Py2 VSS.t8 VSS.t7 nfet_03v3 ad=1.25p pd=3.5u as=2.5p ps=7u w=2.5u l=0.28u
X43 lo.t4 Py2 VDD.t9 VDD.t8 pfet_03v3 ad=2.0825p pd=5.165u as=4.165p ps=10.33u w=4.165u l=0.28u
X44 Ngs en.t2 VSS.t24 VSS.t23 nfet_03v3 ad=0.28p pd=1.56u as=1p ps=4u w=1u l=0.28u
X45 g0s in.t0 x VSS.t29 nfet_03v3 ad=0.14p pd=1.06u as=0.5p ps=3u w=0.5u l=0.28u
R0 lo.n3 lo.t1 7.28638
R1 lo.n3 lo.n2 4.5005
R2 lo lo.n3 2.95629
R3 lo.n2 lo.n1 2.91603
R4 lo.n2 lo.n0 1.33973
R5 lo.n1 lo.t3 1.2605
R6 lo.n1 lo.t2 1.2605
R7 lo.n0 lo.t0 0.840836
R8 lo.n0 lo.t4 0.840836
R9 in.n0 in.t1 27.2192
R10 in.n0 in.t0 25.3957
R11 in in.n0 8.84182
R12 en.n0 en.t5 39.8703
R13 en.n0 en.t2 36.9725
R14 en.n3 en.t3 35.3253
R15 en.n3 en.t0 32.2949
R16 en.n1 en.t4 26.8521
R17 en.n1 en.t1 25.7771
R18 en.n4 en.n3 4.5005
R19 en.n2 en.n1 4.5005
R20 en en.n4 3.72366
R21 en.n2 en.n0 2.79524
R22 en en.n2 2.67445
R23 en.n4 en 2.00655
R24 lob.n1 lob.t4 7.94953
R25 lob.n3 lob.n2 6.80604
R26 lob.n1 lob.n0 6.44971
R27 lob lob.n3 3.09839
R28 lob.n0 lob.t3 1.2605
R29 lob.n0 lob.t1 1.2605
R30 lob.n2 lob.t0 0.840836
R31 lob.n2 lob.t2 0.840836
R32 lob.n3 lob.n1 0.303658
R33 VDD.t31 VDD.t23 567.061
R34 VDD.t27 VDD.t8 428.075
R35 VDD.t29 VDD.t25 428.075
R36 VDD.t33 VDD.t29 428.075
R37 VDD.t43 VDD.t45 428.075
R38 VDD.t6 VDD.t43 428.075
R39 VDD.t14 VDD.t6 428.075
R40 VDD.t0 VDD.t14 428.075
R41 VDD.t47 VDD.t35 428.075
R42 VDD.t37 VDD.t2 428.075
R43 VDD.t2 VDD.t22 428.075
R44 VDD.t22 VDD.t4 428.075
R45 VDD.t23 VDD.t41 428.075
R46 VDD.t39 VDD.t20 428.075
R47 VDD.n87 VDD.t0 316.887
R48 VDD.t10 VDD.t12 177.901
R49 VDD.t8 VDD.t10 177.901
R50 VDD.t25 VDD.t27 177.901
R51 VDD.t45 VDD.t33 177.901
R52 VDD.t35 VDD.t37 177.901
R53 VDD.t4 VDD.t31 177.901
R54 VDD.t41 VDD.t39 177.901
R55 VDD.t20 VDD.t18 177.901
R56 VDD.t18 VDD.t16 177.901
R57 VDD.n87 VDD.t47 111.189
R58 VDD.n107 VDD.t49 47.9016
R59 VDD.n99 VDD.t38 12.0913
R60 VDD.n89 VDD.t36 12.0913
R61 VDD.n90 VDD.t48 6.93804
R62 VDD.n24 VDD.t7 6.93804
R63 VDD.n67 VDD.t44 6.93804
R64 VDD.n114 VDD.t32 6.38103
R65 VDD.n112 VDD.t5 6.38103
R66 VDD.n20 VDD.t1 6.38103
R67 VDD.n28 VDD.t46 6.38103
R68 VDD.n58 VDD.t34 6.38103
R69 VDD.n8 VDD.t24 3.94221
R70 VDD.n56 VDD.t30 3.94221
R71 VDD.n4 VDD.t40 3.273
R72 VDD.n124 VDD.t42 3.273
R73 VDD.n77 VDD.t15 3.273
R74 VDD.n47 VDD.t26 3.273
R75 VDD.n46 VDD.t28 3.273
R76 VDD.n101 VDD.t3 2.26831
R77 VDD.n133 VDD.t21 2.05453
R78 VDD.n36 VDD.t9 2.05453
R79 VDD.n140 VDD.n1 1.57925
R80 VDD.n106 VDD.n105 1.5755
R81 VDD.n109 VDD.n10 1.5755
R82 VDD.n140 VDD.n139 1.5755
R83 VDD.n139 VDD.n138 1.5005
R84 VDD.n3 VDD.n2 1.5005
R85 VDD.n130 VDD.n129 1.5005
R86 VDD.n128 VDD.n127 1.5005
R87 VDD.n7 VDD.n6 1.5005
R88 VDD.n120 VDD.n119 1.5005
R89 VDD.n118 VDD.n117 1.5005
R90 VDD.n11 VDD.n10 1.5005
R91 VDD.n105 VDD.n104 1.5005
R92 VDD.n15 VDD.n14 1.5005
R93 VDD.n96 VDD.n95 1.5005
R94 VDD.n94 VDD.n93 1.5005
R95 VDD.n19 VDD.n18 1.5005
R96 VDD.n84 VDD.n83 1.5005
R97 VDD.n82 VDD.n81 1.5005
R98 VDD.n23 VDD.n22 1.5005
R99 VDD.n74 VDD.n73 1.5005
R100 VDD.n72 VDD.n71 1.5005
R101 VDD.n27 VDD.n26 1.5005
R102 VDD.n64 VDD.n63 1.5005
R103 VDD.n62 VDD.n61 1.5005
R104 VDD.n31 VDD.n30 1.5005
R105 VDD.n53 VDD.n52 1.5005
R106 VDD.n51 VDD.n50 1.5005
R107 VDD.n35 VDD.n34 1.5005
R108 VDD.n43 VDD.n42 1.5005
R109 VDD.n39 VDD.n37 1.5005
R110 VDD.n45 VDD.n44 1.5005
R111 VDD.n49 VDD.n48 1.5005
R112 VDD.n33 VDD.n32 1.5005
R113 VDD.n55 VDD.n54 1.5005
R114 VDD.n60 VDD.n59 1.5005
R115 VDD.n57 VDD.n29 1.5005
R116 VDD.n66 VDD.n65 1.5005
R117 VDD.n70 VDD.n69 1.5005
R118 VDD.n68 VDD.n25 1.5005
R119 VDD.n76 VDD.n75 1.5005
R120 VDD.n80 VDD.n79 1.5005
R121 VDD.n78 VDD.n21 1.5005
R122 VDD.n86 VDD.n85 1.5005
R123 VDD.n92 VDD.n91 1.5005
R124 VDD.n17 VDD.n16 1.5005
R125 VDD.n98 VDD.n97 1.5005
R126 VDD.n103 VDD.n102 1.5005
R127 VDD.n100 VDD.n13 1.5005
R128 VDD.n108 VDD.n12 1.5005
R129 VDD.n111 VDD.n110 1.5005
R130 VDD.n116 VDD.n115 1.5005
R131 VDD.n113 VDD.n9 1.5005
R132 VDD.n122 VDD.n121 1.5005
R133 VDD.n126 VDD.n125 1.5005
R134 VDD.n123 VDD.n5 1.5005
R135 VDD.n132 VDD.n131 1.5005
R136 VDD.n137 VDD.n136 1.5005
R137 VDD.n1 VDD.n0 1.5005
R138 VDD.n135 VDD.n134 1.2142
R139 VDD.n40 VDD.n38 1.2142
R140 VDD.n134 VDD.t19 0.840836
R141 VDD.n134 VDD.t17 0.840836
R142 VDD.n38 VDD.t13 0.840836
R143 VDD.n38 VDD.t11 0.840836
R144 VDD.n42 VDD.n41 0.837843
R145 VDD.n41 VDD.n40 0.800294
R146 VDD.n88 VDD.n87 0.0945299
R147 VDD.n55 VDD.n32 0.0755
R148 VDD.n69 VDD.n68 0.0755
R149 VDD.n79 VDD.n78 0.0755
R150 VDD.n98 VDD.n16 0.0755
R151 VDD.n100 VDD.n12 0.0755
R152 VDD.n111 VDD.n12 0.0755
R153 VDD.n125 VDD.n122 0.0755
R154 VDD.n42 VDD.n34 0.0755
R155 VDD.n51 VDD.n34 0.0755
R156 VDD.n52 VDD.n51 0.0755
R157 VDD.n52 VDD.n30 0.0755
R158 VDD.n62 VDD.n30 0.0755
R159 VDD.n63 VDD.n62 0.0755
R160 VDD.n63 VDD.n26 0.0755
R161 VDD.n72 VDD.n26 0.0755
R162 VDD.n73 VDD.n72 0.0755
R163 VDD.n73 VDD.n22 0.0755
R164 VDD.n82 VDD.n22 0.0755
R165 VDD.n83 VDD.n82 0.0755
R166 VDD.n83 VDD.n18 0.0755
R167 VDD.n94 VDD.n18 0.0755
R168 VDD.n95 VDD.n94 0.0755
R169 VDD.n95 VDD.n14 0.0755
R170 VDD.n105 VDD.n14 0.0755
R171 VDD.n118 VDD.n10 0.0755
R172 VDD.n119 VDD.n118 0.0755
R173 VDD.n119 VDD.n6 0.0755
R174 VDD.n128 VDD.n6 0.0755
R175 VDD.n129 VDD.n128 0.0755
R176 VDD.n129 VDD.n2 0.0755
R177 VDD.n139 VDD.n2 0.0755
R178 VDD.n41 VDD.n37 0.0731183
R179 VDD.n58 VDD.n57 0.0725
R180 VDD.n109 VDD.n108 0.07175
R181 VDD.n110 VDD.n11 0.07175
R182 VDD.n117 VDD.n116 0.07175
R183 VDD.n120 VDD.n9 0.07175
R184 VDD.n121 VDD.n7 0.07175
R185 VDD.n127 VDD.n126 0.07175
R186 VDD.n130 VDD.n5 0.07175
R187 VDD.n131 VDD.n3 0.07175
R188 VDD.n138 VDD.n137 0.07175
R189 VDD.n77 VDD.n76 0.071
R190 VDD.n90 VDD.n89 0.068
R191 VDD.n40 VDD.n39 0.065
R192 VDD.n59 VDD.n56 0.065
R193 VDD.n67 VDD.n66 0.065
R194 VDD.n113 VDD.n8 0.065
R195 VDD.n136 VDD.n135 0.065
R196 VDD.n115 VDD.n112 0.062
R197 VDD.n102 VDD.n99 0.0605
R198 VDD.n102 VDD.n101 0.056
R199 VDD VDD.n0 0.054875
R200 VDD.n91 VDD.n88 0.053
R201 VDD.n48 VDD.n46 0.0515
R202 VDD.n66 VDD.n28 0.0515
R203 VDD.n123 VDD.n4 0.0515
R204 VDD.n44 VDD.n43 0.0486875
R205 VDD.n49 VDD.n35 0.0486875
R206 VDD.n50 VDD.n33 0.0486875
R207 VDD.n54 VDD.n53 0.0486875
R208 VDD.n60 VDD.n31 0.0486875
R209 VDD.n61 VDD.n29 0.0486875
R210 VDD.n65 VDD.n64 0.0486875
R211 VDD.n70 VDD.n27 0.0486875
R212 VDD.n71 VDD.n25 0.0486875
R213 VDD.n75 VDD.n74 0.0486875
R214 VDD.n80 VDD.n23 0.0486875
R215 VDD.n81 VDD.n21 0.0486875
R216 VDD.n85 VDD.n84 0.0486875
R217 VDD.n92 VDD.n19 0.0486875
R218 VDD.n93 VDD.n17 0.0486875
R219 VDD.n97 VDD.n96 0.0486875
R220 VDD.n103 VDD.n15 0.0486875
R221 VDD.n104 VDD.n13 0.0486875
R222 VDD.n48 VDD.n47 0.0455
R223 VDD.n76 VDD.n24 0.0455
R224 VDD.n124 VDD.n123 0.0455
R225 VDD.n107 VDD.n106 0.0455
R226 VDD.n45 VDD.n36 0.044
R227 VDD.n133 VDD.n132 0.044
R228 VDD.n114 VDD.n113 0.041
R229 VDD.n86 VDD.n20 0.0395
R230 VDD.n78 VDD.n20 0.0365
R231 VDD.n115 VDD.n114 0.035
R232 VDD.n39 VDD.n36 0.032
R233 VDD.n136 VDD.n133 0.032
R234 VDD.n47 VDD.n32 0.0305
R235 VDD.n68 VDD.n24 0.0305
R236 VDD.n125 VDD.n124 0.0305
R237 VDD.n43 VDD.n37 0.0273125
R238 VDD.n44 VDD.n35 0.0273125
R239 VDD.n50 VDD.n49 0.0273125
R240 VDD.n53 VDD.n33 0.0273125
R241 VDD.n54 VDD.n31 0.0273125
R242 VDD.n61 VDD.n60 0.0273125
R243 VDD.n64 VDD.n29 0.0273125
R244 VDD.n65 VDD.n27 0.0273125
R245 VDD.n71 VDD.n70 0.0273125
R246 VDD.n74 VDD.n25 0.0273125
R247 VDD.n75 VDD.n23 0.0273125
R248 VDD.n81 VDD.n80 0.0273125
R249 VDD.n84 VDD.n21 0.0273125
R250 VDD.n85 VDD.n19 0.0273125
R251 VDD.n93 VDD.n92 0.0273125
R252 VDD.n96 VDD.n17 0.0273125
R253 VDD.n97 VDD.n15 0.0273125
R254 VDD.n104 VDD.n103 0.0273125
R255 VDD.n106 VDD.n13 0.0273125
R256 VDD.n46 VDD.n45 0.0245
R257 VDD.n57 VDD.n28 0.0245
R258 VDD.n132 VDD.n4 0.0245
R259 VDD.n88 VDD.n86 0.023
R260 VDD.n101 VDD.n100 0.02
R261 VDD VDD.n140 0.017375
R262 VDD.n99 VDD.n98 0.0155
R263 VDD.n112 VDD.n111 0.014
R264 VDD.n56 VDD.n55 0.011
R265 VDD.n69 VDD.n67 0.011
R266 VDD.n122 VDD.n8 0.011
R267 VDD.n135 VDD.n1 0.011
R268 VDD.n89 VDD.n16 0.0065
R269 VDD.n79 VDD.n77 0.005
R270 VDD.n110 VDD.n109 0.00425
R271 VDD.n116 VDD.n11 0.00425
R272 VDD.n117 VDD.n9 0.00425
R273 VDD.n121 VDD.n120 0.00425
R274 VDD.n126 VDD.n7 0.00425
R275 VDD.n127 VDD.n5 0.00425
R276 VDD.n131 VDD.n130 0.00425
R277 VDD.n137 VDD.n3 0.00425
R278 VDD.n138 VDD.n0 0.00425
R279 VDD.n108 VDD.n107 0.0036875
R280 VDD.n59 VDD.n58 0.0035
R281 VDD.n91 VDD.n90 0.002
R282 VSS.t13 VSS.t9 554491
R283 VSS.t37 VSS.t4 1240.19
R284 VSS.t7 VSS.t19 1196.29
R285 VSS.t17 VSS.t30 1196.29
R286 VSS.t30 VSS.t15 1196.29
R287 VSS.t21 VSS.t27 965.808
R288 VSS.t35 VSS.t25 965.808
R289 VSS.t19 VSS.t21 845.082
R290 VSS.t34 VSS.t32 845.082
R291 VSS.t32 VSS.t5 845.082
R292 VSS.t5 VSS.t11 845.082
R293 VSS.t11 VSS.t0 845.082
R294 VSS.t29 VSS.t2 845.082
R295 VSS.t2 VSS.t37 845.082
R296 VSS.t23 VSS.t17 845.082
R297 VSS.n80 VSS.t0 625.581
R298 VSS.t9 VSS.t7 351.204
R299 VSS.t15 VSS.t13 351.204
R300 VSS.t27 VSS.t34 230.477
R301 VSS.t25 VSS.t29 230.477
R302 VSS.t4 VSS.t23 230.477
R303 VSS.n80 VSS.t35 219.502
R304 VSS.n99 VSS.t38 67.3202
R305 VSS.n58 VSS.t33 14.485
R306 VSS.n67 VSS.t6 14.485
R307 VSS.n83 VSS.t36 14.485
R308 VSS.n78 VSS.t1 13.2755
R309 VSS.n15 VSS.t26 13.2755
R310 VSS.n49 VSS.t22 10.8775
R311 VSS.n8 VSS.t18 10.8775
R312 VSS.n26 VSS.t28 6.91629
R313 VSS.n68 VSS.t12 6.91629
R314 VSS.n103 VSS.t24 6.91629
R315 VSS.n92 VSS.t3 4.75708
R316 VSS.n30 VSS.t20 3.64787
R317 VSS.n4 VSS.t31 3.64787
R318 VSS.n34 VSS.t10 2.95866
R319 VSS.n38 VSS.t8 2.95866
R320 VSS.n122 VSS.t16 2.95866
R321 VSS.n1 VSS.t14 2.95866
R322 VSS.n75 VSS.n74 1.5755
R323 VSS.n87 VSS.n86 1.5755
R324 VSS.n97 VSS.n96 1.5755
R325 VSS.n107 VSS.n10 1.5755
R326 VSS.n127 VSS.n126 1.5755
R327 VSS.n127 VSS.n1 1.54175
R328 VSS.n126 VSS.n125 1.5005
R329 VSS.n3 VSS.n2 1.5005
R330 VSS.n118 VSS.n117 1.5005
R331 VSS.n116 VSS.n115 1.5005
R332 VSS.n7 VSS.n6 1.5005
R333 VSS.n109 VSS.n108 1.5005
R334 VSS.n107 VSS.n106 1.5005
R335 VSS.n96 VSS.n95 1.5005
R336 VSS.n14 VSS.n13 1.5005
R337 VSS.n88 VSS.n87 1.5005
R338 VSS.n74 VSS.n19 1.5005
R339 VSS.n73 VSS.n72 1.5005
R340 VSS.n21 VSS.n20 1.5005
R341 VSS.n64 VSS.n63 1.5005
R342 VSS.n62 VSS.n61 1.5005
R343 VSS.n25 VSS.n24 1.5005
R344 VSS.n55 VSS.n54 1.5005
R345 VSS.n53 VSS.n52 1.5005
R346 VSS.n29 VSS.n28 1.5005
R347 VSS.n45 VSS.n44 1.5005
R348 VSS.n43 VSS.n42 1.5005
R349 VSS.n33 VSS.n32 1.5005
R350 VSS.n37 VSS.n36 1.5005
R351 VSS.n41 VSS.n40 1.5005
R352 VSS.n39 VSS.n31 1.5005
R353 VSS.n47 VSS.n46 1.5005
R354 VSS.n51 VSS.n50 1.5005
R355 VSS.n48 VSS.n27 1.5005
R356 VSS.n57 VSS.n56 1.5005
R357 VSS.n60 VSS.n59 1.5005
R358 VSS.n23 VSS.n22 1.5005
R359 VSS.n66 VSS.n65 1.5005
R360 VSS.n70 VSS.n69 1.5005
R361 VSS.n71 VSS.n18 1.5005
R362 VSS.n77 VSS.n76 1.5005
R363 VSS.n79 VSS.n17 1.5005
R364 VSS.n85 VSS.n84 1.5005
R365 VSS.n82 VSS.n16 1.5005
R366 VSS.n90 VSS.n89 1.5005
R367 VSS.n94 VSS.n93 1.5005
R368 VSS.n91 VSS.n12 1.5005
R369 VSS.n98 VSS.n11 1.5005
R370 VSS.n101 VSS.n100 1.5005
R371 VSS.n105 VSS.n104 1.5005
R372 VSS.n102 VSS.n9 1.5005
R373 VSS.n111 VSS.n110 1.5005
R374 VSS.n114 VSS.n113 1.5005
R375 VSS.n112 VSS.n5 1.5005
R376 VSS.n120 VSS.n119 1.5005
R377 VSS.n124 VSS.n123 1.5005
R378 VSS.n121 VSS.n0 1.5005
R379 VSS.n35 VSS.n32 0.839611
R380 VSS.n35 VSS.n34 0.794921
R381 VSS.n36 VSS.n35 0.0786087
R382 VSS.n81 VSS.n80 0.0781119
R383 VSS.n40 VSS.n39 0.0755
R384 VSS.n50 VSS.n47 0.0755
R385 VSS.n59 VSS.n57 0.0755
R386 VSS.n66 VSS.n22 0.0755
R387 VSS.n77 VSS.n18 0.0755
R388 VSS.n93 VSS.n90 0.0755
R389 VSS.n91 VSS.n11 0.0755
R390 VSS.n101 VSS.n11 0.0755
R391 VSS.n104 VSS.n101 0.0755
R392 VSS.n113 VSS.n111 0.0755
R393 VSS.n113 VSS.n112 0.0755
R394 VSS.n123 VSS.n120 0.0755
R395 VSS.n43 VSS.n32 0.0755
R396 VSS.n44 VSS.n43 0.0755
R397 VSS.n44 VSS.n28 0.0755
R398 VSS.n53 VSS.n28 0.0755
R399 VSS.n54 VSS.n53 0.0755
R400 VSS.n54 VSS.n24 0.0755
R401 VSS.n62 VSS.n24 0.0755
R402 VSS.n63 VSS.n62 0.0755
R403 VSS.n63 VSS.n20 0.0755
R404 VSS.n73 VSS.n20 0.0755
R405 VSS.n74 VSS.n73 0.0755
R406 VSS.n87 VSS.n13 0.0755
R407 VSS.n96 VSS.n13 0.0755
R408 VSS.n108 VSS.n107 0.0755
R409 VSS.n108 VSS.n6 0.0755
R410 VSS.n116 VSS.n6 0.0755
R411 VSS.n117 VSS.n116 0.0755
R412 VSS.n117 VSS.n2 0.0755
R413 VSS.n126 VSS.n2 0.0755
R414 VSS.n85 VSS.n17 0.0755
R415 VSS.n83 VSS.n82 0.074
R416 VSS.n104 VSS.n103 0.0725
R417 VSS.n120 VSS.n4 0.0725
R418 VSS.n100 VSS.n10 0.07175
R419 VSS.n106 VSS.n105 0.07175
R420 VSS.n109 VSS.n9 0.07175
R421 VSS.n110 VSS.n7 0.07175
R422 VSS.n115 VSS.n114 0.07175
R423 VSS.n118 VSS.n5 0.07175
R424 VSS.n119 VSS.n3 0.07175
R425 VSS.n125 VSS.n124 0.07175
R426 VSS.n69 VSS.n68 0.071
R427 VSS.n86 VSS.n85 0.06875
R428 VSS.n88 VSS.n16 0.06875
R429 VSS.n89 VSS.n14 0.06875
R430 VSS.n95 VSS.n94 0.06875
R431 VSS.n97 VSS.n12 0.06875
R432 VSS.n37 VSS.n34 0.065
R433 VSS.n49 VSS.n48 0.065
R434 VSS.n59 VSS.n58 0.065
R435 VSS.n90 VSS.n15 0.065
R436 VSS.n102 VSS.n8 0.065
R437 VSS.n122 VSS.n121 0.059
R438 VSS.n57 VSS.n26 0.056
R439 VSS.n93 VSS.n92 0.056
R440 VSS.n41 VSS.n33 0.056
R441 VSS.n42 VSS.n31 0.056
R442 VSS.n46 VSS.n45 0.056
R443 VSS.n51 VSS.n29 0.056
R444 VSS.n52 VSS.n27 0.056
R445 VSS.n56 VSS.n55 0.056
R446 VSS.n60 VSS.n25 0.056
R447 VSS.n61 VSS.n23 0.056
R448 VSS.n65 VSS.n64 0.056
R449 VSS.n70 VSS.n21 0.056
R450 VSS.n72 VSS.n71 0.056
R451 VSS.n76 VSS.n19 0.056
R452 VSS.n75 VSS.n17 0.056
R453 VSS VSS.n0 0.054875
R454 VSS.n84 VSS.n81 0.053
R455 VSS.n39 VSS.n30 0.0455
R456 VSS.n69 VSS.n67 0.0455
R457 VSS.n40 VSS.n38 0.044
R458 VSS.n79 VSS.n78 0.0395
R459 VSS.n99 VSS.n98 0.03875
R460 VSS.n121 VSS.n1 0.038
R461 VSS.n100 VSS.n99 0.03725
R462 VSS.n78 VSS.n77 0.0365
R463 VSS.n38 VSS.n37 0.032
R464 VSS.n47 VSS.n30 0.0305
R465 VSS.n67 VSS.n66 0.0305
R466 VSS.n81 VSS.n79 0.023
R467 VSS.n48 VSS.n26 0.02
R468 VSS.n92 VSS.n91 0.02
R469 VSS.n36 VSS.n33 0.02
R470 VSS.n42 VSS.n41 0.02
R471 VSS.n45 VSS.n31 0.02
R472 VSS.n46 VSS.n29 0.02
R473 VSS.n52 VSS.n51 0.02
R474 VSS.n55 VSS.n27 0.02
R475 VSS.n56 VSS.n25 0.02
R476 VSS.n61 VSS.n60 0.02
R477 VSS.n64 VSS.n23 0.02
R478 VSS.n65 VSS.n21 0.02
R479 VSS.n72 VSS.n70 0.02
R480 VSS.n71 VSS.n19 0.02
R481 VSS.n76 VSS.n75 0.02
R482 VSS VSS.n127 0.017375
R483 VSS.n123 VSS.n122 0.017
R484 VSS.n50 VSS.n49 0.011
R485 VSS.n58 VSS.n22 0.011
R486 VSS.n82 VSS.n15 0.011
R487 VSS.n111 VSS.n8 0.011
R488 VSS.n86 VSS.n16 0.00725
R489 VSS.n89 VSS.n88 0.00725
R490 VSS.n94 VSS.n14 0.00725
R491 VSS.n95 VSS.n12 0.00725
R492 VSS.n98 VSS.n97 0.00725
R493 VSS.n68 VSS.n18 0.005
R494 VSS.n105 VSS.n10 0.00425
R495 VSS.n106 VSS.n9 0.00425
R496 VSS.n110 VSS.n109 0.00425
R497 VSS.n114 VSS.n7 0.00425
R498 VSS.n115 VSS.n5 0.00425
R499 VSS.n119 VSS.n118 0.00425
R500 VSS.n124 VSS.n3 0.00425
R501 VSS.n125 VSS.n0 0.00425
R502 VSS.n103 VSS.n102 0.0035
R503 VSS.n112 VSS.n4 0.0035
R504 VSS.n84 VSS.n83 0.002
C0 Py2 lo 3.02187f
C1 en Ny1 0.00102f
C2 t lo 0.28918f
C3 x lob 0.08182f
C4 lob tb 0.48724f
C5 b lob 0.25839f
C6 lob Ny1 0.20682f
C7 Py2 a 0
C8 Ny0 Ngs 0.07147f
C9 t a 0.00509f
C10 ta in 0.29598f
C11 g0s lo 0
C12 Py2 VDD 0.84617f
C13 VDD t 0.53468f
C14 en Py2 0.70787f
C15 Py1 lo 0.14534f
C16 en t 1.04578f
C17 g0s VDD 0
C18 x in 1.38153f
C19 lob t 0.09542f
C20 in tb 0.03717f
C21 Py1 a 0
C22 b in 1.6034f
C23 b Ngs 0.00888f
C24 en g0s 0.00471f
C25 Py1 VDD 0.56475f
C26 b Py0 0.17687f
C27 lob g0s 0.00261f
C28 Ny2 VDD 0.87593f
C29 en Py1 0.12279f
C30 en Ny2 0
C31 Pgs lo 0
C32 in Py2 0.67175f
C33 Ny2 lob 4.35651f
C34 in t 0.09656f
C35 Pgs a 0.00896f
C36 Py2 Py0 0
C37 lo a 0.47966f
C38 Pgs VDD 0
C39 in g0s 0.00494f
C40 VDD lo 1.6746f
C41 en Pgs 0.00905f
C42 Ny0 tb 0.06857f
C43 Ny0 b 1.41643f
C44 ta x 0
C45 en lo 0.46562f
C46 Ny0 Ny1 1.27426f
C47 ta b 0.06137f
C48 in Py1 0.44552f
C49 VDD a 0.76119f
C50 lob lo 0.40261f
C51 en a 1.31385f
C52 Py1 Py0 1.276f
C53 lob a 0.0038f
C54 en VDD 0.62438f
C55 x tb 0.17958f
C56 x b 0.06191f
C57 b tb 0.80645f
C58 lob VDD 0.98303f
C59 b Ny1 0.00411f
C60 ta t 1.27093f
C61 in Pgs 0.00248f
C62 en lob 0.08077f
C63 in lo 0.09056f
C64 Pgs Py0 0.07271f
C65 Py0 lo 0.53184f
C66 in a 0.15892f
C67 x t 1.7784f
C68 tb t 1.34876f
C69 b t 0.21425f
C70 Py0 a 1.46313f
C71 in VDD 0.13872f
C72 Ngs VDD 0.00217f
C73 Ny0 Ny2 0.00506f
C74 x g0s 0.03739f
C75 en in 1.02618f
C76 VDD Py0 0.35441f
C77 en Ngs 0.00905f
C78 b g0s 0
C79 in lob 0.58091f
C80 lob Ngs 0.00392f
C81 en Py0 0.73089f
C82 b Py1 0
C83 Ny2 Ny1 2.32672f
C84 ta lo 0.10101f
C85 g0s t 0
C86 ta a 1.27941f
C87 Py2 Py1 2.44938f
C88 Ny0 VDD 0.36888f
C89 ta VDD 0.33618f
C90 in Py0 0.0923f
C91 x lo 0.06205f
C92 Ny0 en 0.81999f
C93 tb lo 0.00378f
C94 b lo 0.13724f
C95 ta en 0.07312f
C96 Ny0 lob 0.5145f
C97 x a 0
C98 ta lob 0.02078f
C99 b a 2.81922f
C100 x VDD 0.38363f
C101 tb VDD 1.55451f
C102 b VDD 1.522f
C103 VDD Ny1 0.58929f
C104 x en 0.54597f
C105 en tb 0.06062f
C106 b en 2.94909f
C107 lo VSS 0.837461f
C108 in VSS 0.962127f
C109 en VSS 0.795841f
C110 lob VSS 1.28543f
C111 VDD VSS 51.8373f
C112 Pgs VSS 0.10589f
C113 g0s VSS 0.06752f
C114 Ngs VSS 0.10696f
C115 Py0 VSS 0.7974f
C116 a VSS 1.53504f
C117 x VSS 0.76485f
C118 Py1 VSS 1.17586f
C119 ta VSS 0.84769f
C120 b VSS 2.08213f
C121 Ny0 VSS 0.84821f
C122 tb VSS 1.17359f
C123 Ny1 VSS 1.11824f
C124 t VSS 1.27894f
C125 Py2 VSS 1.63136f
C126 Ny2 VSS 1.67581f
C127 VDD.n0 VSS 0.0194385f
C128 VDD.n1 VSS 0.0620712f
C129 VDD.n2 VSS 0.0501688f
C130 VDD.n3 VSS 0.0250844f
C131 VDD.t21 VSS 0.0343855f
C132 VDD.t40 VSS 0.0207852f
C133 VDD.n4 VSS 0.0493659f
C134 VDD.n5 VSS 0.0250844f
C135 VDD.n6 VSS 0.0501688f
C136 VDD.n7 VSS 0.0250844f
C137 VDD.t24 VSS 0.0165361f
C138 VDD.n8 VSS 0.0483956f
C139 VDD.n9 VSS 0.0250844f
C140 VDD.n10 VSS 0.104754f
C141 VDD.n11 VSS 0.0250844f
C142 VDD.t5 VSS 0.0104135f
C143 VDD.n12 VSS 0.0501688f
C144 VDD.n13 VSS 0.0250844f
C145 VDD.n14 VSS 0.0501688f
C146 VDD.n15 VSS 0.0250844f
C147 VDD.t38 VSS 0.00488473f
C148 VDD.n16 VSS 0.0270918f
C149 VDD.n17 VSS 0.0250844f
C150 VDD.n18 VSS 0.0501688f
C151 VDD.n19 VSS 0.0250844f
C152 VDD.t1 VSS 0.0104135f
C153 VDD.n20 VSS 0.0466809f
C154 VDD.n21 VSS 0.0250844f
C155 VDD.n22 VSS 0.0501688f
C156 VDD.n23 VSS 0.0250844f
C157 VDD.t15 VSS 0.0207852f
C158 VDD.t7 VSS 0.00853991f
C159 VDD.n24 VSS 0.0464551f
C160 VDD.n25 VSS 0.0250844f
C161 VDD.n26 VSS 0.0501688f
C162 VDD.n27 VSS 0.0250844f
C163 VDD.t44 VSS 0.00853991f
C164 VDD.t46 VSS 0.0104135f
C165 VDD.n28 VSS 0.0466809f
C166 VDD.n29 VSS 0.0250844f
C167 VDD.n30 VSS 0.0501688f
C168 VDD.n31 VSS 0.0250844f
C169 VDD.t30 VSS 0.0165361f
C170 VDD.n32 VSS 0.0351132f
C171 VDD.n33 VSS 0.0250844f
C172 VDD.n34 VSS 0.0501688f
C173 VDD.n35 VSS 0.0250844f
C174 VDD.t28 VSS 0.0207852f
C175 VDD.t9 VSS 0.0343855f
C176 VDD.n36 VSS 0.0531716f
C177 VDD.n37 VSS 0.0374551f
C178 VDD.t13 VSS 0.0108819f
C179 VDD.t11 VSS 0.0108819f
C180 VDD.n38 VSS 0.0288985f
C181 VDD.n39 VSS 0.032102f
C182 VDD.n40 VSS 0.120328f
C183 VDD.n41 VSS 0.115502f
C184 VDD.n42 VSS 0.160226f
C185 VDD.n43 VSS 0.0250844f
C186 VDD.n44 VSS 0.0250844f
C187 VDD.n45 VSS 0.0225751f
C188 VDD.n46 VSS 0.0493659f
C189 VDD.t26 VSS 0.0207852f
C190 VDD.n47 VSS 0.0493659f
C191 VDD.n48 VSS 0.032102f
C192 VDD.n49 VSS 0.0250844f
C193 VDD.n50 VSS 0.0250844f
C194 VDD.n51 VSS 0.0501688f
C195 VDD.n52 VSS 0.0501688f
C196 VDD.n53 VSS 0.0250844f
C197 VDD.n54 VSS 0.0250844f
C198 VDD.n55 VSS 0.0285974f
C199 VDD.n56 VSS 0.0483956f
C200 VDD.t34 VSS 0.0104135f
C201 VDD.n57 VSS 0.032102f
C202 VDD.n58 VSS 0.0466809f
C203 VDD.n59 VSS 0.0225751f
C204 VDD.n60 VSS 0.0250844f
C205 VDD.n61 VSS 0.0250844f
C206 VDD.n62 VSS 0.0501688f
C207 VDD.n63 VSS 0.0501688f
C208 VDD.n64 VSS 0.0250844f
C209 VDD.n65 VSS 0.0250844f
C210 VDD.n66 VSS 0.0386261f
C211 VDD.n67 VSS 0.0464551f
C212 VDD.n68 VSS 0.0351132f
C213 VDD.n69 VSS 0.0285974f
C214 VDD.n70 VSS 0.0250844f
C215 VDD.n71 VSS 0.0250844f
C216 VDD.n72 VSS 0.0501688f
C217 VDD.n73 VSS 0.0501688f
C218 VDD.n74 VSS 0.0250844f
C219 VDD.n75 VSS 0.0250844f
C220 VDD.n76 VSS 0.0386261f
C221 VDD.n77 VSS 0.0493659f
C222 VDD.n78 VSS 0.0371206f
C223 VDD.n79 VSS 0.02659f
C224 VDD.n80 VSS 0.0250844f
C225 VDD.n81 VSS 0.0250844f
C226 VDD.n82 VSS 0.0501688f
C227 VDD.n83 VSS 0.0501688f
C228 VDD.n84 VSS 0.0250844f
C229 VDD.n85 VSS 0.0250844f
C230 VDD.n86 VSS 0.0205677f
C231 VDD.t12 VSS 0.165069f
C232 VDD.t10 VSS 0.0962475f
C233 VDD.t8 VSS 0.163931f
C234 VDD.t27 VSS 0.163931f
C235 VDD.t25 VSS 0.163931f
C236 VDD.t29 VSS 0.231606f
C237 VDD.t33 VSS 0.163931f
C238 VDD.t45 VSS 0.163931f
C239 VDD.t43 VSS 0.231606f
C240 VDD.t6 VSS 0.231606f
C241 VDD.t14 VSS 0.231606f
C242 VDD.t0 VSS 0.201528f
C243 VDD.t16 VSS 0.17677f
C244 VDD.t18 VSS 0.0962475f
C245 VDD.t20 VSS 0.163931f
C246 VDD.t39 VSS 0.163931f
C247 VDD.t41 VSS 0.163931f
C248 VDD.t23 VSS 0.269204f
C249 VDD.t31 VSS 0.201528f
C250 VDD.t4 VSS 0.163931f
C251 VDD.t22 VSS 0.231606f
C252 VDD.t2 VSS 0.231606f
C253 VDD.t37 VSS 0.163931f
C254 VDD.t35 VSS 0.163931f
C255 VDD.t47 VSS 0.145881f
C256 VDD.n87 VSS -0.00930105f
C257 VDD.n88 VSS -0.10002f
C258 VDD.t48 VSS 0.00853991f
C259 VDD.t36 VSS 0.00488473f
C260 VDD.n89 VSS 0.0449161f
C261 VDD.n90 VSS 0.0444477f
C262 VDD.n91 VSS 0.0180584f
C263 VDD.n92 VSS 0.0250844f
C264 VDD.n93 VSS 0.0250844f
C265 VDD.n94 VSS 0.0501688f
C266 VDD.n95 VSS 0.0501688f
C267 VDD.n96 VSS 0.0250844f
C268 VDD.n97 VSS 0.0250844f
C269 VDD.n98 VSS 0.030103f
C270 VDD.n99 VSS 0.0454179f
C271 VDD.t3 VSS 0.0310816f
C272 VDD.n100 VSS 0.0316085f
C273 VDD.n101 VSS 0.0521344f
C274 VDD.n102 VSS 0.0386261f
C275 VDD.n103 VSS 0.0250844f
C276 VDD.n104 VSS 0.0250844f
C277 VDD.n105 VSS 0.0860013f
C278 VDD.n106 VSS 0.0258121f
C279 VDD.t49 VSS 0.0134079f
C280 VDD.n107 VSS 0.0609253f
C281 VDD.n108 VSS 0.024892f
C282 VDD.n109 VSS 0.0278112f
C283 VDD.n110 VSS 0.0250844f
C284 VDD.n111 VSS 0.0296011f
C285 VDD.n112 VSS 0.0466809f
C286 VDD.t32 VSS 0.0104135f
C287 VDD.n113 VSS 0.0351132f
C288 VDD.n114 VSS 0.0466809f
C289 VDD.n115 VSS 0.032102f
C290 VDD.n116 VSS 0.0250844f
C291 VDD.n117 VSS 0.0250844f
C292 VDD.n118 VSS 0.0501688f
C293 VDD.n119 VSS 0.0501688f
C294 VDD.n120 VSS 0.0250844f
C295 VDD.n121 VSS 0.0250844f
C296 VDD.n122 VSS 0.0285974f
C297 VDD.t42 VSS 0.0207852f
C298 VDD.n123 VSS 0.032102f
C299 VDD.n124 VSS 0.0493659f
C300 VDD.n125 VSS 0.0351132f
C301 VDD.n126 VSS 0.0250844f
C302 VDD.n127 VSS 0.0250844f
C303 VDD.n128 VSS 0.0501688f
C304 VDD.n129 VSS 0.0501688f
C305 VDD.n130 VSS 0.0250844f
C306 VDD.n131 VSS 0.0250844f
C307 VDD.n132 VSS 0.0225751f
C308 VDD.n133 VSS 0.0531716f
C309 VDD.t19 VSS 0.0108819f
C310 VDD.t17 VSS 0.0108819f
C311 VDD.n134 VSS 0.0288985f
C312 VDD.n135 VSS 0.0368947f
C313 VDD.n136 VSS 0.032102f
C314 VDD.n137 VSS 0.0250844f
C315 VDD.n138 VSS 0.0250844f
C316 VDD.n139 VSS 0.0860013f
C317 VDD.n140 VSS 0.0216216f
C318 lob.t4 VSS 0.372541f
C319 lob.t3 VSS 0.0357158f
C320 lob.t1 VSS 0.0357158f
C321 lob.n0 VSS 0.143705f
C322 lob.n1 VSS 0.141501f
C323 lob.t0 VSS 0.0595011f
C324 lob.t2 VSS 0.0595011f
C325 lob.n2 VSS 0.288117f
C326 lob.n3 VSS 0.194722f
C327 en.t2 VSS 0.0299836f
C328 en.t5 VSS 0.0299904f
C329 en.n0 VSS 0.327681f
C330 en.t4 VSS 0.012218f
C331 en.t1 VSS 0.0117577f
C332 en.n1 VSS 0.175847f
C333 en.n2 VSS 0.275284f
C334 en.t3 VSS 0.0203169f
C335 en.t0 VSS 0.0177979f
C336 en.n3 VSS 0.181913f
C337 en.n4 VSS 0.288399f
C338 in.t1 VSS 0.0131998f
C339 in.t0 VSS 0.0104187f
C340 in.n0 VSS 0.269795f
C341 lo.t1 VSS 0.224312f
C342 lo.t0 VSS 0.0427655f
C343 lo.t4 VSS 0.0427655f
C344 lo.n0 VSS 0.118341f
C345 lo.t3 VSS 0.0256695f
C346 lo.t2 VSS 0.0256695f
C347 lo.n1 VSS 0.0934353f
C348 lo.n2 VSS 0.13657f
C349 lo.n3 VSS 0.17282f
.ends
