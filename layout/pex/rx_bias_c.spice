* rx_bias: magic R+C extraction of layout/rx_bias.gds (layout/gen/pex.sh)
* extracted 2026-11-16T12:08:54+01:00 with magic 8.3.642, mode c, from rx_bias.gds
.subckt rx_bias VDD VSS en enb nb
X0 nr VSS VSS ppolyf_u r_width=2u r_length=29.72u
X1 x VSS vh VDD pfet_03v3 ad=0.42p pd=2.84u as=0.42p ps=2.84u w=0.42u l=10u
X2 nb nb VSS VSS nfet_03v3 ad=2p pd=6u as=2p ps=6u w=2u l=0.5u
X3 vh n2 nb VDD pfet_03v3 ad=2p pd=5u as=4p ps=10u w=4u l=1u
X4 nr nb n2 VSS nfet_03v3 ad=1p pd=3u as=2p ps=6u w=2u l=0.5u
X5 nb x n2 VSS nfet_03v3 ad=1p pd=4u as=1p ps=4u w=1u l=0.28u
X6 n2 n2 vh VDD pfet_03v3 ad=2p pd=5u as=2p ps=5u w=4u l=1u
X7 x enb VSS VSS nfet_03v3 ad=0.42p pd=2.84u as=0.42p ps=2.84u w=0.42u l=0.28u
X8 VSS nb VSS VSS nfet_03v3 ad=4.095p pd=9.19u as=38.02p ps=94.04u w=8.19u l=10u
X9 x nb VSS VSS nfet_03v3 ad=2p pd=6u as=2p ps=6u w=2u l=0.28u
X10 VSS nb VSS VSS nfet_03v3 ad=4.095p pd=9.19u as=0 ps=0 w=8.19u l=10u
X11 n2 nb nr VSS nfet_03v3 ad=2p pd=6u as=1p ps=3u w=2u l=0.5u
X12 nr nb n2 VSS nfet_03v3 ad=1p pd=3u as=2p ps=6u w=2u l=0.5u
X13 enb en VDD VDD pfet_03v3 ad=1p pd=4u as=0.45p ps=2.9u w=1u l=0.28u
X14 vh n2 n2 VDD pfet_03v3 ad=2p pd=5u as=2p ps=5u w=4u l=1u
X15 nb n2 vh VDD pfet_03v3 ad=4p pd=10u as=2p ps=5u w=4u l=1u
X16 enb en VSS VSS nfet_03v3 ad=0.42p pd=2.84u as=0.42p ps=2.84u w=0.42u l=0.28u
X17 VSS nb VSS VSS nfet_03v3 ad=8.19p pd=18.38u as=0 ps=0 w=8.19u l=10u
X18 n2 nb nr VSS nfet_03v3 ad=2p pd=6u as=1p ps=3u w=2u l=0.5u
X19 vh enb VDD VDD pfet_03v3 ad=4p pd=10u as=1.8p ps=8.9u w=4u l=0.28u
X20 nb enb VSS VSS nfet_03v3 ad=0.42p pd=2.84u as=0.42p ps=2.84u w=0.42u l=0.28u
C0 n2 enb 0.23355f
C1 n2 x 1.00468f
C2 vh en 0.01039f
C3 nr enb 0.15069f
C4 nr x 2.01867f
C5 vh n2 2.36305f
C6 n2 en 0.13872f
C7 vh nr 0.00432f
C8 en nr 0.08924f
C9 n2 nr 1.70971f
C10 nb VDD 0.31198f
C11 nb enb 1.59554f
C12 nb x 3.46277f
C13 VDD enb 0.35099f
C14 vh nb 0.50199f
C15 VDD x 0.05397f
C16 en nb 7.0491f
C17 vh VDD 0.88556f
C18 n2 nb 2.72095f
C19 enb x 0.38913f
C20 en VDD 0.15211f
C21 nr nb 1.95029f
C22 n2 VDD 1.20507f
C23 vh enb 0.25426f
C24 vh x 0.04565f
C25 en enb 8.23334f
C26 en x 0.08631f
C27 nr VDD 0.0911f
C28 nb VSS 16.182f
C29 en VSS 1.41894f
C30 enb VSS 3.57452f
C31 VDD VSS 52.0719f
C32 nr VSS 2.21322f
C33 x VSS 1.58537f
C34 vh VSS 0.61522f
C35 n2 VSS 1.95636f
.ends
