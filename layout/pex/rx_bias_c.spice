* rx_bias: magic R+C extraction of layout/rx_bias.gds (layout/gen/pex.sh)
* extracted 2026-11-15T23:54:25+01:00 with magic 8.3.642, mode c, from rx_bias.gds
.subckt rx_bias VDD VSS en enb nb
X0 VSS nr VSS ppolyf_u r_width=2u r_length=29.72u
X1 x nb VSS VSS nfet_03v3 ad=2p pd=6u as=2p ps=6u w=2u l=0.28u
X2 nb x n2 VSS nfet_03v3 ad=1p pd=4u as=1p ps=4u w=1u l=0.28u
X3 VSS nb VSS VSS nfet_03v3 ad=4.095p pd=9.19u as=36.227p ps=89.64u w=8.19u l=10u
X4 enb en VDD VDD pfet_03v3 ad=1p pd=4u as=0.45p ps=2.9u w=1u l=0.28u
X5 n2 n2 vh VDD pfet_03v3 ad=2p pd=5u as=2p ps=5u w=4u l=1u
X6 vh n2 n2 VDD pfet_03v3 ad=2p pd=5u as=2p ps=5u w=4u l=1u
X7 enb en VSS VSS nfet_03v3 ad=0.42p pd=2.84u as=0.189p ps=1.74u w=0.42u l=0.28u
X8 nb nb VSS VSS nfet_03v3 ad=2p pd=6u as=0.9p ps=4.9u w=2u l=0.5u
X9 nr nb n2 VSS nfet_03v3 ad=1p pd=3u as=2p ps=6u w=2u l=0.5u
X10 n2 nb nr VSS nfet_03v3 ad=2p pd=6u as=1p ps=3u w=2u l=0.5u
X11 vh enb VDD VDD pfet_03v3 ad=4p pd=10u as=1.8p ps=8.9u w=4u l=0.28u
X12 VSS nb VSS VSS nfet_03v3 ad=4.095p pd=9.19u as=0 ps=0 w=8.19u l=10u
X13 x enb VSS VSS nfet_03v3 ad=0.42p pd=2.84u as=0.189p ps=1.74u w=0.42u l=0.28u
X14 x VSS vh VDD pfet_03v3 ad=0.42p pd=2.84u as=0.42p ps=2.84u w=0.42u l=10u
X15 nb n2 vh VDD pfet_03v3 ad=4p pd=10u as=2p ps=5u w=4u l=1u
X16 nr nb n2 VSS nfet_03v3 ad=1p pd=3u as=2p ps=6u w=2u l=0.5u
X17 n2 nb nr VSS nfet_03v3 ad=2p pd=6u as=1p ps=3u w=2u l=0.5u
X18 VSS nb VSS VSS nfet_03v3 ad=8.19p pd=18.38u as=0 ps=0 w=8.19u l=10u
X19 vh n2 nb VDD pfet_03v3 ad=2p pd=5u as=4p ps=10u w=4u l=1u
X20 nb enb VSS VSS nfet_03v3 ad=0.42p pd=2.84u as=0.189p ps=1.74u w=0.42u l=0.28u
C0 en VDD 0.43518f
C1 vh en 0.00139f
C2 en nb 0.26886f
C3 en n2 0.18292f
C4 vh VDD 1.29048f
C5 VDD nb 2.51337f
C6 x en 0.03867f
C7 VDD n2 1.59517f
C8 enb en 6.35468f
C9 vh nb 0.784f
C10 vh n2 2.80573f
C11 x VDD 0.90319f
C12 nb n2 3.63931f
C13 enb VDD 0.72196f
C14 nr en 0.08089f
C15 x vh 1.54113f
C16 x nb 2.18179f
C17 enb vh 0.25355f
C18 x n2 0.42354f
C19 enb nb 5.7547f
C20 enb n2 0.11728f
C21 nr VDD 0.56081f
C22 x enb 0.45325f
C23 nr vh 0.04885f
C24 nr nb 2.47068f
C25 nr n2 1.21756f
C26 x nr 0.01134f
C27 enb nr 0.04735f
C28 en VSS 2.98873f
C29 enb VSS 1.76876f
C30 nb VSS 19.6801f
C31 VDD VSS 48.2768f
C32 vh VSS 1.06954f
C33 nr VSS 1.4407f
C34 n2 VSS 2.66427f
C35 x VSS 1.85652f
.ends
