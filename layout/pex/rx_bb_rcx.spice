* rx_bb: magic R+C extraction of layout/rx_bb.gds (layout/gen/pex.sh)
* rcfix.py: split-net C to VSS scaled by (S - K) / S on 7 nets (coupling double count removed)
* extracted 2026-11-16T12:09:01+01:00 with magic 8.3.642, mode rc, from rx_bb.gds
.subckt rx_bb VDD VSS inp inn outp outn nb enb
X0 t1 inp.t11 o1n VSS.t45 nfet_03v3 ad=10p pd=21u as=10p ps=21u w=20u l=1u
X1 t2 nb.t1 VSS.t34 VSS.t33 nfet_03v3 ad=0.3304p pd=2.76u as=0.1774p ps=1.74u w=0.3u l=0.5u
X2 VSS.t3 o2p VSS.t3 VSS.t2 nfet_03v3 ad=24.57p pd=51.14u as=0 ps=0 w=24.57u l=10u
X3 g2n vgr vb vb pfet_03v3 ad=0.42p pd=2.84u as=0.42p ps=2.84u w=0.42u l=12u
X4 o2p g3p o2p o2p pfet_03v3 ad=12.285p pd=26.57u as=36.855p ps=79.71u w=12.285u l=10u
X5 o1n inp.t14 t1 VSS.t42 nfet_03v3 ad=10p pd=21u as=10p ps=21u w=20u l=1u
X6 t1 inp.t1 o1n VSS.t55 nfet_03v3 ad=10p pd=21u as=10p ps=21u w=20u l=1u
X7 o1n g2n o1n o1n pfet_03v3 ad=12.285p pd=26.57u as=36.855p ps=79.71u w=12.285u l=10u
X8 t1 inp.t5 o1n VSS.t51 nfet_03v3 ad=10p pd=21u as=10p ps=21u w=20u l=1u
X9 VSS.t80 outp.t3 VSS.t80 VSS.t79 nfet_03v3 ad=12.285p pd=25.57u as=0 ps=0 w=24.57u l=10u
X10 VSS.t9 o2p VSS.t9 VSS.t8 nfet_03v3 ad=12.285p pd=25.57u as=0 ps=0 w=24.57u l=10u
X11 g2p vgr vb vb pfet_03v3 ad=0.42p pd=2.84u as=0.42p ps=2.84u w=0.42u l=12u
X12 g3n vgr vb vb pfet_03v3 ad=0.42p pd=2.84u as=0.42p ps=2.84u w=0.42u l=12u
X13 o1n inp.t8 t1 VSS.t48 nfet_03v3 ad=10p pd=21u as=10p ps=21u w=20u l=1u
X14 t1 inn.t10 o1p VSS.t62 nfet_03v3 ad=10p pd=21u as=10p ps=21u w=20u l=1u
X15 t2 g2p o2n VSS.t23 nfet_03v3 ad=2p pd=5u as=4p ps=10u w=4u l=1u
X16 VSS.t7 o2p VSS.t7 VSS.t6 nfet_03v3 ad=12.285p pd=25.57u as=0 ps=0 w=24.57u l=10u
X17 VDD.t5 outp.t2 VSS.t26 ppolyf_u_1k r_width=1u r_length=0.2m
X18 t1 inn.t0 o1p VSS.t72 nfet_03v3 ad=10p pd=21u as=10p ps=21u w=20u l=1u
X19 outp.t0 g3n t3 VSS.t16 nfet_03v3 ad=2p pd=5u as=2p ps=5u w=4u l=1u
X20 VDD.t4 o1n VSS.t25 ppolyf_u r_width=2u r_length=57.14u
X21 o1p inn.t13 t1 VSS.t59 nfet_03v3 ad=10p pd=21u as=10p ps=21u w=20u l=1u
X22 t1 inn.t4 o1p VSS.t68 nfet_03v3 ad=10p pd=21u as=10p ps=21u w=20u l=1u
X23 o1p inn.t3 t1 VSS.t69 nfet_03v3 ad=10p pd=21u as=10p ps=21u w=20u l=1u
X24 VSS.t40 nb.t2 t1 VSS.t39 nfet_03v3 ad=3.6p pd=16.9u as=4p ps=9u w=8u l=0.5u
X25 VSS.t13 o2n VSS.t13 VSS.t8 nfet_03v3 ad=12.285p pd=25.57u as=0 ps=0 w=24.57u l=10u
X26 mRp2a mRp2a vb vb pfet_03v3 ad=0.42p pd=2.84u as=0.42p ps=2.84u w=0.42u l=1u
X27 mRp2a mRp2a g2p g2p pfet_03v3 ad=0.42p pd=2.84u as=0.42p ps=2.84u w=0.42u l=1u
X28 VSS.t5 o2p VSS.t5 VSS.t4 nfet_03v3 ad=12.285p pd=25.57u as=0 ps=0 w=24.57u l=10u
X29 o1p g2p o1p o1p pfet_03v3 ad=6.1425p pd=13.285u as=36.855p ps=79.71u w=12.285u l=10u
X30 o1p inn.t7 t1 VSS.t65 nfet_03v3 ad=10p pd=21u as=10p ps=21u w=20u l=1u
X31 t1 inp.t15 o1n VSS.t41 nfet_03v3 ad=10p pd=21u as=20p ps=42u w=20u l=1u
X32 t1 inp.t9 o1n VSS.t47 nfet_03v3 ad=10p pd=21u as=10p ps=21u w=20u l=1u
X33 VSS.t81 outn.t6 VSS.t81 VSS.t73 nfet_03v3 ad=24.57p pd=51.14u as=0 ps=0 w=24.57u l=10u
X34 mRp3a mRp3a vb vb pfet_03v3 ad=0.42p pd=2.84u as=0.42p ps=2.84u w=0.42u l=1u
X35 outn.t1 g3p t3 VSS.t1 nfet_03v3 ad=4p pd=10u as=2p ps=5u w=4u l=1u
X36 o1n inp.t12 t1 VSS.t44 nfet_03v3 ad=10p pd=21u as=10p ps=21u w=20u l=1u
X37 o1n inp.t2 t1 VSS.t54 nfet_03v3 ad=10p pd=21u as=10p ps=21u w=20u l=1u
X38 vb VSS.t20 VSS.t19 ppolyf_u_1k r_width=1u r_length=99.99u
X39 t1 inn.t14 o1p VSS.t58 nfet_03v3 ad=10p pd=21u as=10p ps=21u w=20u l=1u
X40 t2 g2n o2p VSS.t28 nfet_03v3 ad=2p pd=5u as=2p ps=5u w=4u l=1u
X41 VSS.t78 outp.t4 VSS.t78 VSS.t77 nfet_03v3 ad=12.285p pd=25.57u as=0 ps=0 w=24.57u l=10u
X42 o1n inp.t6 t1 VSS.t50 nfet_03v3 ad=10p pd=21u as=10p ps=21u w=20u l=1u
X43 VSS.t32 nb.t4 vgr VSS.t31 nfet_03v3 ad=0.189p pd=1.74u as=0.42p ps=2.84u w=0.42u l=50u
X44 t1 inn.t8 o1p VSS.t64 nfet_03v3 ad=10p pd=21u as=10p ps=21u w=20u l=1u
X45 VSS.t82 outn.t5 VSS.t82 VSS.t75 nfet_03v3 ad=12.285p pd=25.57u as=0 ps=0 w=24.57u l=10u
X46 VSS.t84 outn.t3 VSS.t84 VSS.t79 nfet_03v3 ad=12.285p pd=25.57u as=0 ps=0 w=24.57u l=10u
X47 VSS.t76 outp.t5 VSS.t76 VSS.t75 nfet_03v3 ad=12.285p pd=25.57u as=0 ps=0 w=24.57u l=10u
X48 vgr vgr vb vb pfet_03v3 ad=4p pd=10u as=4p ps=10u w=4u l=1u
X49 o1p g2p o1p o1p pfet_03v3 ad=12.285p pd=26.57u as=0 ps=0 w=12.285u l=10u
X50 o1p inn.t11 t1 VSS.t61 nfet_03v3 ad=10p pd=21u as=10p ps=21u w=20u l=1u
X51 o1p inn.t1 t1 VSS.t71 nfet_03v3 ad=10p pd=21u as=10p ps=21u w=20u l=1u
X52 VDD.t2 o2p VSS.t15 ppolyf_u_1k r_width=1u r_length=0.2m
X53 o2n g3n o2n o2n pfet_03v3 ad=6.1425p pd=13.285u as=36.855p ps=79.71u w=12.285u l=10u
X54 t1 inp.t13 o1n VSS.t43 nfet_03v3 ad=10p pd=21u as=10p ps=21u w=20u l=1u
X55 t3 nb.t0 VSS.t36 VSS.t35 nfet_03v3 ad=0.8p pd=3.6u as=0.36p ps=2.5u w=0.8u l=0.5u
X56 VSS.t11 o2n VSS.t11 VSS.t4 nfet_03v3 ad=12.285p pd=25.57u as=0 ps=0 w=24.57u l=10u
X57 VSS.t22 vb VSS.t22 VSS.t21 nfet_03v3 ad=24.57p pd=51.14u as=0 ps=0 w=24.57u l=10u
X58 mRp2b mRp2b vb vb pfet_03v3 ad=0.42p pd=2.84u as=0.42p ps=2.84u w=0.42u l=1u
X59 o1p inn.t5 t1 VSS.t67 nfet_03v3 ad=10p pd=21u as=10p ps=21u w=20u l=1u
X60 t1 inp.t3 o1n VSS.t53 nfet_03v3 ad=10p pd=21u as=10p ps=21u w=20u l=1u
X61 VSS.t10 o2n VSS.t10 VSS.t2 nfet_03v3 ad=24.57p pd=51.14u as=0 ps=0 w=24.57u l=10u
X62 VSS.t74 outp.t6 VSS.t74 VSS.t73 nfet_03v3 ad=24.57p pd=51.14u as=0 ps=0 w=24.57u l=10u
X63 vb vbt VSS.t14 ppolyf_u_1k r_width=1u r_length=0.15002m
X64 VDD.t6 o1p VSS.t29 ppolyf_u r_width=2u r_length=57.14u
X65 t1 inp.t7 o1n VSS.t49 nfet_03v3 ad=10p pd=21u as=10p ps=21u w=20u l=1u
X66 t1 nb.t3 VSS.t38 VSS.t37 nfet_03v3 ad=4p pd=9u as=3.6p ps=16.9u w=8u l=0.5u
X67 mRp3a mRp3a g3p g3p pfet_03v3 ad=0.42p pd=2.84u as=0.42p ps=2.84u w=0.42u l=1u
X68 mRp3b mRp3b g3n g3n pfet_03v3 ad=0.42p pd=2.84u as=0.42p ps=2.84u w=0.42u l=1u
X69 vbt enb.t0 VDD.t1 VDD.t0 pfet_03v3 ad=1p pd=4u as=0.45p ps=2.9u w=1u l=0.28u
X70 t3 g3p outn.t0 VSS.t0 nfet_03v3 ad=2p pd=5u as=4p ps=10u w=4u l=1u
X71 VDD.t3 o2n VSS.t18 ppolyf_u_1k r_width=1u r_length=0.2m
X72 o1n inp.t10 t1 VSS.t46 nfet_03v3 ad=10p pd=21u as=10p ps=21u w=20u l=1u
X73 o1n inp.t0 t1 VSS.t56 nfet_03v3 ad=20p pd=42u as=10p ps=21u w=20u l=1u
X74 t1 inn.t12 o1p VSS.t60 nfet_03v3 ad=10p pd=21u as=10p ps=21u w=20u l=1u
X75 mRp2b mRp2b g2n g2n pfet_03v3 ad=0.42p pd=2.84u as=0.42p ps=2.84u w=0.42u l=1u
X76 t1 inn.t2 o1p VSS.t70 nfet_03v3 ad=10p pd=21u as=10p ps=21u w=20u l=1u
X77 VDD.t7 outn.t2 VSS.t30 ppolyf_u_1k r_width=1u r_length=0.2m
X78 g3p vgr vb vb pfet_03v3 ad=0.42p pd=2.84u as=0.42p ps=2.84u w=0.42u l=12u
X79 o2n g3n o2n o2n pfet_03v3 ad=12.285p pd=26.57u as=0 ps=0 w=12.285u l=10u
X80 o1p inn.t15 t1 VSS.t57 nfet_03v3 ad=10p pd=21u as=10p ps=21u w=20u l=1u
X81 o2p g2n t2 VSS.t27 nfet_03v3 ad=2p pd=5u as=2p ps=5u w=4u l=1u
X82 o2p g3p o2p o2p pfet_03v3 ad=6.1425p pd=13.285u as=0 ps=0 w=12.285u l=10u
X83 VSS.t83 outn.t4 VSS.t83 VSS.t77 nfet_03v3 ad=12.285p pd=25.57u as=0 ps=0 w=24.57u l=10u
X84 o1n g2n o1n o1n pfet_03v3 ad=6.1425p pd=13.285u as=0 ps=0 w=12.285u l=10u
X85 t3 g3n outp.t1 VSS.t17 nfet_03v3 ad=2p pd=5u as=2p ps=5u w=4u l=1u
X86 o1n inp.t4 t1 VSS.t52 nfet_03v3 ad=10p pd=21u as=10p ps=21u w=20u l=1u
X87 t1 inn.t6 o1p VSS.t66 nfet_03v3 ad=10p pd=21u as=10p ps=21u w=20u l=1u
X88 VSS.t12 o2n VSS.t12 VSS.t6 nfet_03v3 ad=12.285p pd=25.57u as=0 ps=0 w=24.57u l=10u
X89 mRp3b mRp3b vb vb pfet_03v3 ad=0.42p pd=2.84u as=0.42p ps=2.84u w=0.42u l=1u
X90 o2n g2p t2 VSS.t24 nfet_03v3 ad=4p pd=10u as=2p ps=5u w=4u l=1u
X91 o1p inn.t9 t1 VSS.t63 nfet_03v3 ad=10p pd=21u as=10p ps=21u w=20u l=1u
R0 nb.n2 nb.t3 80.8909
R1 nb.n2 nb.t2 80.5357
R2 nb.n0 nb.t0 30.2399
R3 nb.n1 nb.t1 26.7239
R4 nb nb.n3 24.5208
R5 nb.n0 nb.t4 15.334
R6 nb.n3 nb.n2 3.24524
R7 nb.n1 nb.n0 2.93497
R8 nb nb.n1 0.141421
R9 nb.n3 nb 0.0348421
R10 inn.n6 inn.t15 90.0019
R11 inn.n0 inn.t0 90.0019
R12 inn.n6 inn.t14 89.5282
R13 inn.n7 inn.t13 89.5282
R14 inn.n8 inn.t12 89.5282
R15 inn.n9 inn.t11 89.5282
R16 inn.n10 inn.t10 89.5282
R17 inn.n11 inn.t9 89.5282
R18 inn.n12 inn.t8 89.5282
R19 inn.n13 inn.t7 89.5282
R20 inn.n5 inn.t6 89.5282
R21 inn.n4 inn.t5 89.5282
R22 inn.n3 inn.t4 89.5282
R23 inn.n2 inn.t3 89.5282
R24 inn.n1 inn.t2 89.5282
R25 inn.n0 inn.t1 89.5282
R26 inn inn.n14 25.0039
R27 inn.n1 inn.n0 1.42155
R28 inn.n3 inn.n2 1.42155
R29 inn.n5 inn.n4 1.42155
R30 inn.n11 inn.n10 1.42155
R31 inn.n9 inn.n8 1.42155
R32 inn.n7 inn.n6 1.42155
R33 inn.n13 inn 0.711026
R34 inn inn.n12 0.711026
R35 inn.n2 inn.n1 0.474184
R36 inn.n4 inn.n3 0.474184
R37 inn.n12 inn.n11 0.474184
R38 inn.n10 inn.n9 0.474184
R39 inn.n8 inn.n7 0.474184
R40 inn.n14 inn.n5 0.384184
R41 inn.n14 inn.n13 0.0905
R42 inp.n6 inp.t15 90.6272
R43 inp.n0 inp.t0 90.6272
R44 inp.n6 inp.t14 89.2061
R45 inp.n7 inp.t13 89.2061
R46 inp.n8 inp.t12 89.2061
R47 inp.n9 inp.t11 89.2061
R48 inp.n10 inp.t10 89.2061
R49 inp.n11 inp.t9 89.2061
R50 inp.n12 inp.t8 89.2061
R51 inp.n13 inp.t7 89.2061
R52 inp.n5 inp.t6 89.2061
R53 inp.n4 inp.t5 89.2061
R54 inp.n3 inp.t4 89.2061
R55 inp.n2 inp.t3 89.2061
R56 inp.n1 inp.t2 89.2061
R57 inp.n0 inp.t1 89.2061
R58 inp inp.n14 24.6818
R59 inp.n2 inp.n1 1.42155
R60 inp.n4 inp.n3 1.42155
R61 inp.n12 inp.n11 1.42155
R62 inp.n10 inp.n9 1.42155
R63 inp.n8 inp.n7 1.42155
R64 inp.n14 inp.n5 1.17997
R65 inp.n1 inp.n0 0.474184
R66 inp.n3 inp.n2 0.474184
R67 inp.n5 inp.n4 0.474184
R68 inp.n11 inp.n10 0.474184
R69 inp.n9 inp.n8 0.474184
R70 inp.n7 inp.n6 0.474184
R71 inp.n14 inp.n13 0.242079
R72 inp.n13 inp 0.237342
R73 inp inp.n12 0.237342
R74 enb enb.t0 38.126
R75 outp.n0 outp.t6 25.5793
R76 outp.n2 outp.t3 23.5756
R77 outp.n0 outp.t5 22.9741
R78 outp.n1 outp.t4 22.9741
R79 outp.n4 outp.n2 17.2237
R80 outp outp.t2 16.1644
R81 outp outp.n3 11.6709
R82 outp.n5 outp 8.07682
R83 outp outp.n5 6.78721
R84 outp.n5 outp.n4 6.76471
R85 outp.n4 outp 5.73563
R86 outp.n2 outp.n1 2.00418
R87 outp.n1 outp 1.30313
R88 outp outp.n0 1.30313
R89 outp.n3 outp.t1 0.788
R90 outp.n3 outp.t0 0.788
R91 outn.n0 outn.t6 24.5621
R92 outn.n2 outn.t3 24.491
R93 outn.n0 outn.t5 21.9568
R94 outn.n1 outn.t4 21.9568
R95 outn.n4 outn.n2 16.7405
R96 outn outn.t2 14.2412
R97 outn.n3 outn.t1 12.7959
R98 outn.n3 outn.t0 10.9012
R99 outn.n5 outn.n4 7.89208
R100 outn.n4 outn 7.17563
R101 outn.n5 outn 6.95892
R102 outn outn.n5 5.98195
R103 outn.n1 outn 1.30313
R104 outn outn.n0 1.30313
R105 outn outn.n3 0.780895
R106 outn.n2 outn.n1 0.0715526
R107 VDD.n30 VDD.t0 49266.7
R108 VDD.n91 VDD.t5 16.2733
R109 VDD.n94 VDD.n93 12.4252
R110 VDD.n93 VDD.t3 12.1049
R111 VDD.n92 VDD.t2 12.1049
R112 VDD.n91 VDD.t7 12.1049
R113 VDD.n96 VDD.n95 11.4921
R114 VDD.n95 VDD.t4 8.73247
R115 VDD.n94 VDD.t6 8.73247
R116 VDD.n109 VDD.t1 7.57826
R117 VDD.n92 VDD.n91 4.16892
R118 VDD.n93 VDD.n92 4.16892
R119 VDD.n95 VDD.n94 2.91366
R120 VDD.n103 VDD.n3 1.5755
R121 VDD.n105 VDD.n104 1.5755
R122 VDD.n67 VDD.n12 1.5755
R123 VDD.n84 VDD.n83 1.5755
R124 VDD.n50 VDD.n49 1.5755
R125 VDD.n60 VDD.n59 1.5755
R126 VDD.n34 VDD.n29 1.5755
R127 VDD.n43 VDD.n42 1.5755
R128 VDD VDD.n109 1.54681
R129 VDD.n108 VDD.n0 1.5005
R130 VDD.n107 VDD.n106 1.5005
R131 VDD.n101 VDD.n1 1.5005
R132 VDD.n100 VDD.n99 1.5005
R133 VDD.n98 VDD.n97 1.5005
R134 VDD.n90 VDD.n4 1.5005
R135 VDD.n89 VDD.n88 1.5005
R136 VDD.n87 VDD.n5 1.5005
R137 VDD.n86 VDD.n85 1.5005
R138 VDD.n80 VDD.n6 1.5005
R139 VDD.n79 VDD.n78 1.5005
R140 VDD.n77 VDD.n76 1.5005
R141 VDD.n11 VDD.n10 1.5005
R142 VDD.n71 VDD.n70 1.5005
R143 VDD.n69 VDD.n68 1.5005
R144 VDD.n66 VDD.n14 1.5005
R145 VDD.n65 VDD.n64 1.5005
R146 VDD.n63 VDD.n15 1.5005
R147 VDD.n62 VDD.n61 1.5005
R148 VDD.n56 VDD.n16 1.5005
R149 VDD.n55 VDD.n54 1.5005
R150 VDD.n53 VDD.n52 1.5005
R151 VDD.n21 VDD.n20 1.5005
R152 VDD.n48 VDD.n47 1.5005
R153 VDD.n46 VDD.n22 1.5005
R154 VDD.n45 VDD.n44 1.5005
R155 VDD.n24 VDD.n23 1.5005
R156 VDD.n40 VDD.n39 1.5005
R157 VDD.n38 VDD.n37 1.5005
R158 VDD.n28 VDD.n27 1.5005
R159 VDD.n32 VDD.n31 1.5005
R160 VDD.n34 VDD.n33 1.5005
R161 VDD.n36 VDD.n35 1.5005
R162 VDD.n26 VDD.n25 1.5005
R163 VDD.n42 VDD.n41 1.5005
R164 VDD.n51 VDD.n50 1.5005
R165 VDD.n19 VDD.n18 1.5005
R166 VDD.n58 VDD.n57 1.5005
R167 VDD.n59 VDD.n17 1.5005
R168 VDD.n13 VDD.n12 1.5005
R169 VDD.n73 VDD.n72 1.5005
R170 VDD.n75 VDD.n74 1.5005
R171 VDD.n9 VDD.n8 1.5005
R172 VDD.n82 VDD.n81 1.5005
R173 VDD.n83 VDD.n7 1.5005
R174 VDD.n103 VDD.n102 1.5005
R175 VDD.n104 VDD.n2 1.5005
R176 VDD.n30 VDD.n29 0.4126
R177 VDD.n31 VDD.n30 0.101446
R178 VDD.n104 VDD.n103 0.0755
R179 VDD.n73 VDD.n12 0.0755
R180 VDD.n74 VDD.n73 0.0755
R181 VDD.n74 VDD.n8 0.0755
R182 VDD.n82 VDD.n8 0.0755
R183 VDD.n83 VDD.n82 0.0755
R184 VDD.n50 VDD.n18 0.0755
R185 VDD.n58 VDD.n18 0.0755
R186 VDD.n59 VDD.n58 0.0755
R187 VDD.n35 VDD.n34 0.0755
R188 VDD.n35 VDD.n25 0.0755
R189 VDD.n42 VDD.n25 0.0755
R190 VDD.n31 VDD.n27 0.0755
R191 VDD.n38 VDD.n27 0.0755
R192 VDD.n39 VDD.n38 0.0755
R193 VDD.n39 VDD.n23 0.0755
R194 VDD.n45 VDD.n23 0.0755
R195 VDD.n46 VDD.n45 0.0755
R196 VDD.n47 VDD.n46 0.0755
R197 VDD.n47 VDD.n20 0.0755
R198 VDD.n53 VDD.n20 0.0755
R199 VDD.n54 VDD.n53 0.0755
R200 VDD.n54 VDD.n16 0.0755
R201 VDD.n62 VDD.n16 0.0755
R202 VDD.n63 VDD.n62 0.0755
R203 VDD.n64 VDD.n63 0.0755
R204 VDD.n64 VDD.n14 0.0755
R205 VDD.n69 VDD.n14 0.0755
R206 VDD.n70 VDD.n69 0.0755
R207 VDD.n70 VDD.n10 0.0755
R208 VDD.n77 VDD.n10 0.0755
R209 VDD.n78 VDD.n77 0.0755
R210 VDD.n78 VDD.n6 0.0755
R211 VDD.n86 VDD.n6 0.0755
R212 VDD.n87 VDD.n86 0.0755
R213 VDD.n88 VDD.n87 0.0755
R214 VDD.n88 VDD.n4 0.0755
R215 VDD.n98 VDD.n4 0.0755
R216 VDD.n99 VDD.n98 0.0755
R217 VDD.n99 VDD.n1 0.0755
R218 VDD.n107 VDD.n1 0.0755
R219 VDD.n108 VDD.n107 0.0755
R220 VDD.n44 VDD.n22 0.0755
R221 VDD.n48 VDD.n22 0.0755
R222 VDD.n65 VDD.n15 0.0755
R223 VDD.n66 VDD.n65 0.0755
R224 VDD.n89 VDD.n5 0.0755
R225 VDD.n90 VDD.n89 0.0755
R226 VDD.n49 VDD.n48 0.0695
R227 VDD.n51 VDD.n21 0.0695
R228 VDD.n52 VDD.n19 0.0695
R229 VDD.n57 VDD.n55 0.0695
R230 VDD.n56 VDD.n17 0.0695
R231 VDD.n61 VDD.n60 0.0695
R232 VDD.n67 VDD.n66 0.059
R233 VDD.n68 VDD.n13 0.059
R234 VDD.n72 VDD.n71 0.059
R235 VDD.n75 VDD.n11 0.059
R236 VDD.n76 VDD.n9 0.059
R237 VDD.n81 VDD.n79 0.059
R238 VDD.n80 VDD.n7 0.059
R239 VDD.n85 VDD.n84 0.059
R240 VDD.n96 VDD.n90 0.0575
R241 VDD VDD.n0 0.054875
R242 VDD.n109 VDD.n108 0.0498125
R243 VDD.n97 VDD.n3 0.0455
R244 VDD.n102 VDD.n100 0.0455
R245 VDD.n101 VDD.n2 0.0455
R246 VDD.n106 VDD.n105 0.0455
R247 VDD.n32 VDD.n29 0.044
R248 VDD.n33 VDD.n28 0.044
R249 VDD.n37 VDD.n36 0.044
R250 VDD.n40 VDD.n26 0.044
R251 VDD.n41 VDD.n24 0.044
R252 VDD.n44 VDD.n43 0.044
R253 VDD.n33 VDD.n32 0.032
R254 VDD.n36 VDD.n28 0.032
R255 VDD.n37 VDD.n26 0.032
R256 VDD.n41 VDD.n40 0.032
R257 VDD.n43 VDD.n24 0.032
R258 VDD.n100 VDD.n3 0.0305
R259 VDD.n102 VDD.n101 0.0305
R260 VDD.n106 VDD.n2 0.0305
R261 VDD.n105 VDD.n0 0.0305
R262 VDD.n97 VDD.n96 0.0185
R263 VDD.n68 VDD.n67 0.017
R264 VDD.n71 VDD.n13 0.017
R265 VDD.n72 VDD.n11 0.017
R266 VDD.n76 VDD.n75 0.017
R267 VDD.n79 VDD.n9 0.017
R268 VDD.n81 VDD.n80 0.017
R269 VDD.n85 VDD.n7 0.017
R270 VDD.n84 VDD.n5 0.017
R271 VDD.n49 VDD.n21 0.0065
R272 VDD.n52 VDD.n51 0.0065
R273 VDD.n55 VDD.n19 0.0065
R274 VDD.n57 VDD.n56 0.0065
R275 VDD.n61 VDD.n17 0.0065
R276 VDD.n60 VDD.n15 0.0065
R277 VSS.n142 VSS.t41 190208
R278 VSS.n142 VSS.n138 102435
R279 VSS.n136 VSS.n135 93830.7
R280 VSS.n141 VSS.n139 85099.4
R281 VSS.n139 VSS.n43 57765.4
R282 VSS.n131 VSS.n43 57765.4
R283 VSS.n133 VSS.n131 55765.5
R284 VSS.t25 VSS.n142 36146.7
R285 VSS.n134 VSS.n133 34867.8
R286 VSS.n140 VSS.n139 26745.6
R287 VSS.n132 VSS.n131 26745.6
R288 VSS.n133 VSS.t19 9866.66
R289 VSS.n135 VSS.n134 9745.46
R290 VSS.n137 VSS.n136 4878.65
R291 VSS.n138 VSS.n137 4805.62
R292 VSS.n144 VSS.n137 3785.29
R293 VSS.n143 VSS.n138 3785.29
R294 VSS.n145 VSS.n136 3386.84
R295 VSS.n135 VSS.t30 1165.82
R296 VSS.n143 VSS.t14 924.426
R297 VSS.n145 VSS.n144 718.043
R298 VSS.n144 VSS.n143 707.293
R299 VSS.t29 VSS.t25 354.721
R300 VSS.t14 VSS.t29 300.976
R301 VSS.t26 VSS.t30 247.231
R302 VSS.t30 VSS.t15 247.231
R303 VSS.t18 VSS.t15 247.231
R304 VSS.t19 VSS.t35 192.358
R305 VSS.t0 VSS.t33 165.337
R306 VSS.t37 VSS.t56 145.78
R307 VSS.t79 VSS.t24 138.669
R308 VSS.t77 VSS.t39 113.779
R309 VSS.t1 VSS.t17 71.1126
R310 VSS.t17 VSS.t16 71.1126
R311 VSS.t16 VSS.t0 71.1126
R312 VSS.t24 VSS.t28 71.1126
R313 VSS.t28 VSS.t27 71.1126
R314 VSS.t27 VSS.t23 71.1126
R315 VSS.t55 VSS.t71 71.1126
R316 VSS.t54 VSS.t55 71.1126
R317 VSS.t70 VSS.t54 71.1126
R318 VSS.t69 VSS.t70 71.1126
R319 VSS.t52 VSS.t53 71.1126
R320 VSS.t68 VSS.t52 71.1126
R321 VSS.t67 VSS.t68 71.1126
R322 VSS.t51 VSS.t67 71.1126
R323 VSS.t50 VSS.t51 71.1126
R324 VSS.t65 VSS.t66 71.1126
R325 VSS.t49 VSS.t65 71.1126
R326 VSS.t48 VSS.t49 71.1126
R327 VSS.t64 VSS.t48 71.1126
R328 VSS.t46 VSS.t47 71.1126
R329 VSS.t62 VSS.t46 71.1126
R330 VSS.t61 VSS.t62 71.1126
R331 VSS.t45 VSS.t61 71.1126
R332 VSS.t60 VSS.t44 71.1126
R333 VSS.t59 VSS.t60 71.1126
R334 VSS.t43 VSS.t59 71.1126
R335 VSS.t42 VSS.t43 71.1126
R336 VSS.t58 VSS.t42 71.1126
R337 VSS.n132 VSS.t31 69.3348
R338 VSS.t18 VSS.n145 64.4953
R339 VSS.t71 VSS.t75 64.0014
R340 VSS.t8 VSS.t50 64.0014
R341 VSS.t4 VSS.t45 64.0014
R342 VSS.t21 VSS.t1 60.8013
R343 VSS.n141 VSS.t57 60.268
R344 VSS.t72 VSS.n43 56.7124
R345 VSS.t39 VSS.t37 53.3346
R346 VSS.t73 VSS.t69 42.6678
R347 VSS.t47 VSS.t6 42.6678
R348 VSS.t57 VSS.t2 42.6678
R349 VSS.n140 VSS.t64 42.3122
R350 VSS.t23 VSS.t77 39.1121
R351 VSS.t63 VSS.n140 28.8009
R352 VSS.t53 VSS.t73 28.4453
R353 VSS.t6 VSS.t63 28.4453
R354 VSS.t2 VSS.t58 28.4453
R355 VSS.n90 VSS.t20 28.1213
R356 VSS.t35 VSS.n132 14.5785
R357 VSS.n642 VSS.t56 13.1562
R358 VSS.n340 VSS.t32 12.6629
R359 VSS.n367 VSS.t34 11.9381
R360 VSS.n146 VSS.t18 11.8749
R361 VSS.t41 VSS.n141 10.8451
R362 VSS.n356 VSS.t36 8.62422
R363 VSS.t33 VSS.t79 8.53395
R364 VSS.t75 VSS.t72 7.11171
R365 VSS.t66 VSS.t8 7.11171
R366 VSS.t44 VSS.t4 7.11171
R367 VSS.n134 VSS.t26 6.45314
R368 VSS.n447 VSS.n339 5.23875
R369 VSS.n730 VSS.n2 5.23044
R370 VSS.n448 VSS.n447 4.25708
R371 VSS.n731 VSS.n730 4.1749
R372 VSS.n728 VSS.t10 3.30157
R373 VSS.n30 VSS.t13 3.30157
R374 VSS.n667 VSS.t81 3.30157
R375 VSS.t84 VSS.n363 3.30157
R376 VSS.n475 VSS.t22 3.30157
R377 VSS.t22 VSS.n77 3.30157
R378 VSS.n493 VSS.t80 3.30157
R379 VSS.n616 VSS.t74 3.30157
R380 VSS.t9 VSS.n531 3.30157
R381 VSS.t3 VSS.n1 3.30157
R382 VSS.n601 VSS.n538 3.17336
R383 VSS.n569 VSS.n556 3.17336
R384 VSS.n685 VSS.n25 3.17336
R385 VSS.n717 VSS.n8 3.17336
R386 VSS.n701 VSS.n17 3.17336
R387 VSS.n665 VSS.n664 3.17336
R388 VSS.n380 VSS.n379 3.17336
R389 VSS.n378 VSS.n368 3.17336
R390 VSS.n509 VSS.n69 3.17336
R391 VSS.n529 VSS.n528 3.17336
R392 VSS.n530 VSS.n51 3.17336
R393 VSS.n585 VSS.n547 3.17336
R394 VSS.n377 VSS.t40 1.66925
R395 VSS.n381 VSS.t38 1.66925
R396 VSS.n447 VSS.n446 1.58268
R397 VSS.n449 VSS.n93 1.5755
R398 VSS.n458 VSS.n457 1.5755
R399 VSS.n598 VSS.n537 1.5755
R400 VSS.n565 VSS.n564 1.5755
R401 VSS.n505 VSS.n504 1.5755
R402 VSS.n605 VSS.n533 1.5755
R403 VSS.n464 VSS.n87 1.5755
R404 VSS.n498 VSS.n72 1.5755
R405 VSS.n430 VSS.n347 1.5755
R406 VSS.n415 VSS.n354 1.5755
R407 VSS.n445 VSS.n444 1.5755
R408 VSS.n437 VSS.n436 1.5755
R409 VSS.n688 VSS.n24 1.5755
R410 VSS.n723 VSS.n722 1.5755
R411 VSS.n671 VSS.n32 1.5755
R412 VSS.n681 VSS.n680 1.5755
R413 VSS.n647 VSS.n38 1.5755
R414 VSS.n660 VSS.n659 1.5755
R415 VSS.n386 VSS.n385 1.5755
R416 VSS.n374 VSS.n41 1.5755
R417 VSS.n393 VSS.n392 1.5755
R418 VSS.n392 VSS.n370 1.5755
R419 VSS.n408 VSS.n359 1.5755
R420 VSS.n400 VSS.n399 1.5755
R421 VSS.n274 VSS.n273 1.5755
R422 VSS.n187 VSS.n185 1.5755
R423 VSS.n282 VSS.n281 1.5755
R424 VSS.n281 VSS.n124 1.5755
R425 VSS.n338 VSS.n337 1.5755
R426 VSS.n289 VSS.n121 1.5755
R427 VSS.n729 VSS.n728 1.54175
R428 VSS.n731 VSS.n1 1.54175
R429 VSS.n727 VSS.n3 1.5005
R430 VSS.n726 VSS.n725 1.5005
R431 VSS.n724 VSS.n4 1.5005
R432 VSS.n718 VSS.n5 1.5005
R433 VSS.n720 VSS.n719 1.5005
R434 VSS.n717 VSS.n716 1.5005
R435 VSS.n10 VSS.n9 1.5005
R436 VSS.n711 VSS.n710 1.5005
R437 VSS.n709 VSS.n708 1.5005
R438 VSS.n14 VSS.n13 1.5005
R439 VSS.n703 VSS.n702 1.5005
R440 VSS.n700 VSS.n699 1.5005
R441 VSS.n19 VSS.n18 1.5005
R442 VSS.n694 VSS.n693 1.5005
R443 VSS.n692 VSS.n691 1.5005
R444 VSS.n23 VSS.n22 1.5005
R445 VSS.n686 VSS.n685 1.5005
R446 VSS.n684 VSS.n683 1.5005
R447 VSS.n682 VSS.n26 1.5005
R448 VSS.n676 VSS.n27 1.5005
R449 VSS.n678 VSS.n677 1.5005
R450 VSS.n675 VSS.n674 1.5005
R451 VSS.n666 VSS.n31 1.5005
R452 VSS.n669 VSS.n668 1.5005
R453 VSS.n656 VSS.n33 1.5005
R454 VSS.n658 VSS.n657 1.5005
R455 VSS.n37 VSS.n35 1.5005
R456 VSS.n663 VSS.n662 1.5005
R457 VSS.n652 VSS.n34 1.5005
R458 VSS.n651 VSS.n650 1.5005
R459 VSS.n649 VSS.n648 1.5005
R460 VSS.n646 VSS.n40 1.5005
R461 VSS.n645 VSS.n644 1.5005
R462 VSS.n375 VSS.n42 1.5005
R463 VSS.n383 VSS.n382 1.5005
R464 VSS.n373 VSS.n372 1.5005
R465 VSS.n388 VSS.n387 1.5005
R466 VSS.n390 VSS.n389 1.5005
R467 VSS.n371 VSS.n369 1.5005
R468 VSS.n395 VSS.n394 1.5005
R469 VSS.n396 VSS.n366 1.5005
R470 VSS.n398 VSS.n397 1.5005
R471 VSS.n365 VSS.n364 1.5005
R472 VSS.n403 VSS.n402 1.5005
R473 VSS.n405 VSS.n404 1.5005
R474 VSS.n360 VSS.n358 1.5005
R475 VSS.n411 VSS.n410 1.5005
R476 VSS.n409 VSS.n408 1.5005
R477 VSS.n407 VSS.n406 1.5005
R478 VSS.n362 VSS.n361 1.5005
R479 VSS.n401 VSS.n400 1.5005
R480 VSS.n392 VSS.n391 1.5005
R481 VSS.n385 VSS.n384 1.5005
R482 VSS.n376 VSS.n374 1.5005
R483 VSS.n39 VSS.n38 1.5005
R484 VSS.n654 VSS.n653 1.5005
R485 VSS.n655 VSS.n36 1.5005
R486 VSS.n661 VSS.n660 1.5005
R487 VSS.n671 VSS.n670 1.5005
R488 VSS.n673 VSS.n672 1.5005
R489 VSS.n29 VSS.n28 1.5005
R490 VSS.n680 VSS.n679 1.5005
R491 VSS.n688 VSS.n687 1.5005
R492 VSS.n690 VSS.n689 1.5005
R493 VSS.n21 VSS.n20 1.5005
R494 VSS.n696 VSS.n695 1.5005
R495 VSS.n698 VSS.n697 1.5005
R496 VSS.n16 VSS.n15 1.5005
R497 VSS.n705 VSS.n704 1.5005
R498 VSS.n707 VSS.n706 1.5005
R499 VSS.n12 VSS.n11 1.5005
R500 VSS.n713 VSS.n712 1.5005
R501 VSS.n715 VSS.n714 1.5005
R502 VSS.n7 VSS.n6 1.5005
R503 VSS.n722 VSS.n721 1.5005
R504 VSS.n444 VSS.n443 1.5005
R505 VSS.n343 VSS.n342 1.5005
R506 VSS.n438 VSS.n437 1.5005
R507 VSS.n431 VSS.n430 1.5005
R508 VSS.n429 VSS.n428 1.5005
R509 VSS.n351 VSS.n350 1.5005
R510 VSS.n423 VSS.n422 1.5005
R511 VSS.n421 VSS.n420 1.5005
R512 VSS.n355 VSS.n354 1.5005
R513 VSS.n412 VSS.n357 1.5005
R514 VSS.n414 VSS.n413 1.5005
R515 VSS.n417 VSS.n416 1.5005
R516 VSS.n419 VSS.n418 1.5005
R517 VSS.n353 VSS.n352 1.5005
R518 VSS.n425 VSS.n424 1.5005
R519 VSS.n427 VSS.n426 1.5005
R520 VSS.n349 VSS.n348 1.5005
R521 VSS.n433 VSS.n432 1.5005
R522 VSS.n435 VSS.n434 1.5005
R523 VSS.n346 VSS.n345 1.5005
R524 VSS.n440 VSS.n439 1.5005
R525 VSS.n442 VSS.n441 1.5005
R526 VSS.n344 VSS.n341 1.5005
R527 VSS.n730 VSS.n729 1.5005
R528 VSS.n337 VSS.n336 1.5005
R529 VSS.n98 VSS.n97 1.5005
R530 VSS.n331 VSS.n330 1.5005
R531 VSS.n329 VSS.n328 1.5005
R532 VSS.n102 VSS.n101 1.5005
R533 VSS.n323 VSS.n322 1.5005
R534 VSS.n321 VSS.n320 1.5005
R535 VSS.n106 VSS.n105 1.5005
R536 VSS.n315 VSS.n314 1.5005
R537 VSS.n313 VSS.n312 1.5005
R538 VSS.n110 VSS.n109 1.5005
R539 VSS.n307 VSS.n306 1.5005
R540 VSS.n305 VSS.n304 1.5005
R541 VSS.n114 VSS.n113 1.5005
R542 VSS.n299 VSS.n298 1.5005
R543 VSS.n297 VSS.n296 1.5005
R544 VSS.n118 VSS.n117 1.5005
R545 VSS.n291 VSS.n290 1.5005
R546 VSS.n289 VSS.n288 1.5005
R547 VSS.n281 VSS.n280 1.5005
R548 VSS.n273 VSS.n272 1.5005
R549 VSS.n129 VSS.n128 1.5005
R550 VSS.n267 VSS.n266 1.5005
R551 VSS.n265 VSS.n264 1.5005
R552 VSS.n149 VSS.n148 1.5005
R553 VSS.n259 VSS.n258 1.5005
R554 VSS.n257 VSS.n256 1.5005
R555 VSS.n154 VSS.n153 1.5005
R556 VSS.n251 VSS.n250 1.5005
R557 VSS.n249 VSS.n248 1.5005
R558 VSS.n158 VSS.n157 1.5005
R559 VSS.n243 VSS.n242 1.5005
R560 VSS.n241 VSS.n240 1.5005
R561 VSS.n162 VSS.n161 1.5005
R562 VSS.n235 VSS.n234 1.5005
R563 VSS.n233 VSS.n232 1.5005
R564 VSS.n166 VSS.n165 1.5005
R565 VSS.n227 VSS.n226 1.5005
R566 VSS.n225 VSS.n224 1.5005
R567 VSS.n170 VSS.n169 1.5005
R568 VSS.n219 VSS.n218 1.5005
R569 VSS.n217 VSS.n216 1.5005
R570 VSS.n174 VSS.n173 1.5005
R571 VSS.n211 VSS.n210 1.5005
R572 VSS.n209 VSS.n208 1.5005
R573 VSS.n178 VSS.n177 1.5005
R574 VSS.n203 VSS.n202 1.5005
R575 VSS.n201 VSS.n200 1.5005
R576 VSS.n182 VSS.n181 1.5005
R577 VSS.n195 VSS.n194 1.5005
R578 VSS.n193 VSS.n192 1.5005
R579 VSS.n186 VSS.n185 1.5005
R580 VSS.n189 VSS.n188 1.5005
R581 VSS.n191 VSS.n190 1.5005
R582 VSS.n184 VSS.n183 1.5005
R583 VSS.n197 VSS.n196 1.5005
R584 VSS.n199 VSS.n198 1.5005
R585 VSS.n180 VSS.n179 1.5005
R586 VSS.n205 VSS.n204 1.5005
R587 VSS.n207 VSS.n206 1.5005
R588 VSS.n176 VSS.n175 1.5005
R589 VSS.n213 VSS.n212 1.5005
R590 VSS.n215 VSS.n214 1.5005
R591 VSS.n172 VSS.n171 1.5005
R592 VSS.n221 VSS.n220 1.5005
R593 VSS.n223 VSS.n222 1.5005
R594 VSS.n168 VSS.n167 1.5005
R595 VSS.n229 VSS.n228 1.5005
R596 VSS.n231 VSS.n230 1.5005
R597 VSS.n164 VSS.n163 1.5005
R598 VSS.n237 VSS.n236 1.5005
R599 VSS.n239 VSS.n238 1.5005
R600 VSS.n160 VSS.n159 1.5005
R601 VSS.n245 VSS.n244 1.5005
R602 VSS.n247 VSS.n246 1.5005
R603 VSS.n156 VSS.n155 1.5005
R604 VSS.n253 VSS.n252 1.5005
R605 VSS.n255 VSS.n254 1.5005
R606 VSS.n152 VSS.n151 1.5005
R607 VSS.n261 VSS.n260 1.5005
R608 VSS.n263 VSS.n262 1.5005
R609 VSS.n150 VSS.n147 1.5005
R610 VSS.n269 VSS.n268 1.5005
R611 VSS.n271 VSS.n270 1.5005
R612 VSS.n130 VSS.n127 1.5005
R613 VSS.n275 VSS.n126 1.5005
R614 VSS.n277 VSS.n276 1.5005
R615 VSS.n279 VSS.n278 1.5005
R616 VSS.n125 VSS.n123 1.5005
R617 VSS.n283 VSS.n122 1.5005
R618 VSS.n285 VSS.n284 1.5005
R619 VSS.n287 VSS.n286 1.5005
R620 VSS.n120 VSS.n119 1.5005
R621 VSS.n293 VSS.n292 1.5005
R622 VSS.n295 VSS.n294 1.5005
R623 VSS.n116 VSS.n115 1.5005
R624 VSS.n301 VSS.n300 1.5005
R625 VSS.n303 VSS.n302 1.5005
R626 VSS.n112 VSS.n111 1.5005
R627 VSS.n309 VSS.n308 1.5005
R628 VSS.n311 VSS.n310 1.5005
R629 VSS.n108 VSS.n107 1.5005
R630 VSS.n317 VSS.n316 1.5005
R631 VSS.n319 VSS.n318 1.5005
R632 VSS.n104 VSS.n103 1.5005
R633 VSS.n325 VSS.n324 1.5005
R634 VSS.n327 VSS.n326 1.5005
R635 VSS.n100 VSS.n99 1.5005
R636 VSS.n333 VSS.n332 1.5005
R637 VSS.n335 VSS.n334 1.5005
R638 VSS.n96 VSS.n95 1.5005
R639 VSS.n560 VSS.n0 1.5005
R640 VSS.n561 VSS.n559 1.5005
R641 VSS.n563 VSS.n562 1.5005
R642 VSS.n558 VSS.n557 1.5005
R643 VSS.n568 VSS.n567 1.5005
R644 VSS.n570 VSS.n569 1.5005
R645 VSS.n553 VSS.n552 1.5005
R646 VSS.n576 VSS.n575 1.5005
R647 VSS.n578 VSS.n577 1.5005
R648 VSS.n549 VSS.n548 1.5005
R649 VSS.n584 VSS.n583 1.5005
R650 VSS.n587 VSS.n586 1.5005
R651 VSS.n544 VSS.n543 1.5005
R652 VSS.n593 VSS.n592 1.5005
R653 VSS.n595 VSS.n594 1.5005
R654 VSS.n540 VSS.n539 1.5005
R655 VSS.n601 VSS.n600 1.5005
R656 VSS.n603 VSS.n602 1.5005
R657 VSS.n604 VSS.n536 1.5005
R658 VSS.n607 VSS.n606 1.5005
R659 VSS.n609 VSS.n608 1.5005
R660 VSS.n535 VSS.n532 1.5005
R661 VSS.n615 VSS.n614 1.5005
R662 VSS.n618 VSS.n617 1.5005
R663 VSS.n57 VSS.n56 1.5005
R664 VSS.n624 VSS.n623 1.5005
R665 VSS.n626 VSS.n625 1.5005
R666 VSS.n55 VSS.n52 1.5005
R667 VSS.n632 VSS.n631 1.5005
R668 VSS.n634 VSS.n633 1.5005
R669 VSS.n47 VSS.n45 1.5005
R670 VSS.n640 VSS.n639 1.5005
R671 VSS.n62 VSS.n44 1.5005
R672 VSS.n527 VSS.n526 1.5005
R673 VSS.n520 VSS.n60 1.5005
R674 VSS.n519 VSS.n518 1.5005
R675 VSS.n517 VSS.n516 1.5005
R676 VSS.n66 VSS.n65 1.5005
R677 VSS.n511 VSS.n510 1.5005
R678 VSS.n508 VSS.n507 1.5005
R679 VSS.n71 VSS.n70 1.5005
R680 VSS.n503 VSS.n502 1.5005
R681 VSS.n501 VSS.n500 1.5005
R682 VSS.n74 VSS.n73 1.5005
R683 VSS.n495 VSS.n494 1.5005
R684 VSS.n492 VSS.n491 1.5005
R685 VSS.n484 VSS.n78 1.5005
R686 VSS.n486 VSS.n485 1.5005
R687 VSS.n483 VSS.n482 1.5005
R688 VSS.n82 VSS.n81 1.5005
R689 VSS.n477 VSS.n476 1.5005
R690 VSS.n474 VSS.n473 1.5005
R691 VSS.n86 VSS.n85 1.5005
R692 VSS.n468 VSS.n467 1.5005
R693 VSS.n466 VSS.n465 1.5005
R694 VSS.n88 VSS.n87 1.5005
R695 VSS.n470 VSS.n469 1.5005
R696 VSS.n472 VSS.n471 1.5005
R697 VSS.n84 VSS.n83 1.5005
R698 VSS.n479 VSS.n478 1.5005
R699 VSS.n481 VSS.n480 1.5005
R700 VSS.n80 VSS.n79 1.5005
R701 VSS.n488 VSS.n487 1.5005
R702 VSS.n490 VSS.n489 1.5005
R703 VSS.n76 VSS.n75 1.5005
R704 VSS.n497 VSS.n496 1.5005
R705 VSS.n499 VSS.n498 1.5005
R706 VSS.n506 VSS.n505 1.5005
R707 VSS.n68 VSS.n67 1.5005
R708 VSS.n513 VSS.n512 1.5005
R709 VSS.n515 VSS.n514 1.5005
R710 VSS.n64 VSS.n63 1.5005
R711 VSS.n522 VSS.n521 1.5005
R712 VSS.n523 VSS.n61 1.5005
R713 VSS.n525 VSS.n524 1.5005
R714 VSS.n48 VSS.n46 1.5005
R715 VSS.n638 VSS.n637 1.5005
R716 VSS.n636 VSS.n635 1.5005
R717 VSS.n50 VSS.n49 1.5005
R718 VSS.n630 VSS.n629 1.5005
R719 VSS.n628 VSS.n627 1.5005
R720 VSS.n54 VSS.n53 1.5005
R721 VSS.n622 VSS.n621 1.5005
R722 VSS.n620 VSS.n619 1.5005
R723 VSS.n59 VSS.n58 1.5005
R724 VSS.n613 VSS.n612 1.5005
R725 VSS.n611 VSS.n610 1.5005
R726 VSS.n534 VSS.n533 1.5005
R727 VSS.n599 VSS.n598 1.5005
R728 VSS.n597 VSS.n596 1.5005
R729 VSS.n542 VSS.n541 1.5005
R730 VSS.n591 VSS.n590 1.5005
R731 VSS.n589 VSS.n588 1.5005
R732 VSS.n546 VSS.n545 1.5005
R733 VSS.n582 VSS.n581 1.5005
R734 VSS.n580 VSS.n579 1.5005
R735 VSS.n551 VSS.n550 1.5005
R736 VSS.n574 VSS.n573 1.5005
R737 VSS.n572 VSS.n571 1.5005
R738 VSS.n555 VSS.n554 1.5005
R739 VSS.n566 VSS.n565 1.5005
R740 VSS.n94 VSS.n93 1.5005
R741 VSS.n456 VSS.n455 1.5005
R742 VSS.n457 VSS.n92 1.5005
R743 VSS.n463 VSS.n89 1.5005
R744 VSS.n462 VSS.n461 1.5005
R745 VSS.n460 VSS.n459 1.5005
R746 VSS.n454 VSS.n91 1.5005
R747 VSS.n453 VSS.n452 1.5005
R748 VSS.n451 VSS.n450 1.5005
R749 VSS.n642 VSS.n43 1.24496
R750 VSS.t31 VSS.t21 1.06718
R751 VSS.n189 VSS.n2 0.585263
R752 VSS.n339 VSS.n95 0.584164
R753 VSS.n451 VSS.n448 0.584164
R754 VSS.n446 VSS.n340 0.546851
R755 VSS.n538 VSS.t9 0.128705
R756 VSS.t7 VSS.n538 0.128705
R757 VSS.n556 VSS.t5 0.128705
R758 VSS.n556 VSS.t3 0.128705
R759 VSS.t13 VSS.n25 0.128705
R760 VSS.n25 VSS.t12 0.128705
R761 VSS.t11 VSS.n8 0.128705
R762 VSS.n8 VSS.t10 0.128705
R763 VSS.t12 VSS.n17 0.128705
R764 VSS.n17 VSS.t11 0.128705
R765 VSS.n665 VSS.t82 0.128705
R766 VSS.t81 VSS.n665 0.128705
R767 VSS.n379 VSS.t83 0.128705
R768 VSS.n379 VSS.t82 0.128705
R769 VSS.n378 VSS.t84 0.128705
R770 VSS.t83 VSS.n378 0.128705
R771 VSS.t80 VSS.n69 0.128705
R772 VSS.n69 VSS.t78 0.128705
R773 VSS.n529 VSS.t78 0.128705
R774 VSS.t76 VSS.n529 0.128705
R775 VSS.n530 VSS.t76 0.128705
R776 VSS.t74 VSS.n530 0.128705
R777 VSS.n547 VSS.t7 0.128705
R778 VSS.t5 VSS.n547 0.128705
R779 VSS.n187 VSS.n2 0.117112
R780 VSS.n446 VSS.n445 0.0990866
R781 VSS.n449 VSS.n448 0.0990866
R782 VSS.n339 VSS.n338 0.0784616
R783 VSS.n456 VSS.n93 0.0755
R784 VSS.n457 VSS.n456 0.0755
R785 VSS.n598 VSS.n597 0.0755
R786 VSS.n597 VSS.n541 0.0755
R787 VSS.n590 VSS.n541 0.0755
R788 VSS.n590 VSS.n589 0.0755
R789 VSS.n589 VSS.n545 0.0755
R790 VSS.n581 VSS.n545 0.0755
R791 VSS.n581 VSS.n580 0.0755
R792 VSS.n580 VSS.n550 0.0755
R793 VSS.n573 VSS.n550 0.0755
R794 VSS.n573 VSS.n572 0.0755
R795 VSS.n572 VSS.n554 0.0755
R796 VSS.n565 VSS.n554 0.0755
R797 VSS.n505 VSS.n67 0.0755
R798 VSS.n513 VSS.n67 0.0755
R799 VSS.n514 VSS.n513 0.0755
R800 VSS.n514 VSS.n63 0.0755
R801 VSS.n522 VSS.n63 0.0755
R802 VSS.n523 VSS.n522 0.0755
R803 VSS.n524 VSS.n523 0.0755
R804 VSS.n524 VSS.n48 0.0755
R805 VSS.n637 VSS.n48 0.0755
R806 VSS.n637 VSS.n636 0.0755
R807 VSS.n636 VSS.n49 0.0755
R808 VSS.n629 VSS.n49 0.0755
R809 VSS.n629 VSS.n628 0.0755
R810 VSS.n628 VSS.n53 0.0755
R811 VSS.n621 VSS.n53 0.0755
R812 VSS.n621 VSS.n620 0.0755
R813 VSS.n620 VSS.n58 0.0755
R814 VSS.n612 VSS.n58 0.0755
R815 VSS.n612 VSS.n611 0.0755
R816 VSS.n611 VSS.n533 0.0755
R817 VSS.n470 VSS.n87 0.0755
R818 VSS.n471 VSS.n470 0.0755
R819 VSS.n471 VSS.n83 0.0755
R820 VSS.n479 VSS.n83 0.0755
R821 VSS.n480 VSS.n479 0.0755
R822 VSS.n480 VSS.n79 0.0755
R823 VSS.n488 VSS.n79 0.0755
R824 VSS.n489 VSS.n488 0.0755
R825 VSS.n489 VSS.n75 0.0755
R826 VSS.n497 VSS.n75 0.0755
R827 VSS.n498 VSS.n497 0.0755
R828 VSS.n430 VSS.n429 0.0755
R829 VSS.n429 VSS.n350 0.0755
R830 VSS.n422 VSS.n350 0.0755
R831 VSS.n422 VSS.n421 0.0755
R832 VSS.n421 VSS.n354 0.0755
R833 VSS.n444 VSS.n342 0.0755
R834 VSS.n437 VSS.n342 0.0755
R835 VSS.n689 VSS.n688 0.0755
R836 VSS.n689 VSS.n20 0.0755
R837 VSS.n696 VSS.n20 0.0755
R838 VSS.n697 VSS.n696 0.0755
R839 VSS.n697 VSS.n15 0.0755
R840 VSS.n705 VSS.n15 0.0755
R841 VSS.n706 VSS.n705 0.0755
R842 VSS.n706 VSS.n11 0.0755
R843 VSS.n713 VSS.n11 0.0755
R844 VSS.n714 VSS.n713 0.0755
R845 VSS.n714 VSS.n6 0.0755
R846 VSS.n722 VSS.n6 0.0755
R847 VSS.n672 VSS.n671 0.0755
R848 VSS.n672 VSS.n28 0.0755
R849 VSS.n680 VSS.n28 0.0755
R850 VSS.n654 VSS.n38 0.0755
R851 VSS.n655 VSS.n654 0.0755
R852 VSS.n660 VSS.n655 0.0755
R853 VSS.n385 VSS.n374 0.0755
R854 VSS.n408 VSS.n407 0.0755
R855 VSS.n407 VSS.n361 0.0755
R856 VSS.n400 VSS.n361 0.0755
R857 VSS.n441 VSS.n344 0.0755
R858 VSS.n441 VSS.n440 0.0755
R859 VSS.n440 VSS.n345 0.0755
R860 VSS.n434 VSS.n345 0.0755
R861 VSS.n434 VSS.n433 0.0755
R862 VSS.n433 VSS.n348 0.0755
R863 VSS.n426 VSS.n348 0.0755
R864 VSS.n426 VSS.n425 0.0755
R865 VSS.n425 VSS.n352 0.0755
R866 VSS.n418 VSS.n352 0.0755
R867 VSS.n418 VSS.n417 0.0755
R868 VSS.n413 VSS.n412 0.0755
R869 VSS.n412 VSS.n411 0.0755
R870 VSS.n411 VSS.n358 0.0755
R871 VSS.n404 VSS.n403 0.0755
R872 VSS.n403 VSS.n364 0.0755
R873 VSS.n397 VSS.n396 0.0755
R874 VSS.n396 VSS.n395 0.0755
R875 VSS.n389 VSS.n371 0.0755
R876 VSS.n389 VSS.n388 0.0755
R877 VSS.n388 VSS.n372 0.0755
R878 VSS.n644 VSS.n42 0.0755
R879 VSS.n649 VSS.n40 0.0755
R880 VSS.n650 VSS.n649 0.0755
R881 VSS.n650 VSS.n34 0.0755
R882 VSS.n663 VSS.n35 0.0755
R883 VSS.n657 VSS.n35 0.0755
R884 VSS.n657 VSS.n33 0.0755
R885 VSS.n668 VSS.n33 0.0755
R886 VSS.n677 VSS.n675 0.0755
R887 VSS.n677 VSS.n676 0.0755
R888 VSS.n676 VSS.n26 0.0755
R889 VSS.n684 VSS.n26 0.0755
R890 VSS.n685 VSS.n684 0.0755
R891 VSS.n685 VSS.n22 0.0755
R892 VSS.n692 VSS.n22 0.0755
R893 VSS.n693 VSS.n692 0.0755
R894 VSS.n693 VSS.n18 0.0755
R895 VSS.n700 VSS.n18 0.0755
R896 VSS.n702 VSS.n13 0.0755
R897 VSS.n709 VSS.n13 0.0755
R898 VSS.n710 VSS.n709 0.0755
R899 VSS.n710 VSS.n9 0.0755
R900 VSS.n717 VSS.n9 0.0755
R901 VSS.n719 VSS.n717 0.0755
R902 VSS.n719 VSS.n718 0.0755
R903 VSS.n718 VSS.n4 0.0755
R904 VSS.n726 VSS.n4 0.0755
R905 VSS.n727 VSS.n726 0.0755
R906 VSS.n414 VSS.n357 0.0755
R907 VSS.n398 VSS.n366 0.0755
R908 VSS.n394 VSS.n366 0.0755
R909 VSS.n646 VSS.n645 0.0755
R910 VSS.n658 VSS.n656 0.0755
R911 VSS.n683 VSS.n682 0.0755
R912 VSS.n725 VSS.n724 0.0755
R913 VSS.n725 VSS.n3 0.0755
R914 VSS.n273 VSS.n128 0.0755
R915 VSS.n266 VSS.n128 0.0755
R916 VSS.n266 VSS.n265 0.0755
R917 VSS.n265 VSS.n148 0.0755
R918 VSS.n258 VSS.n148 0.0755
R919 VSS.n258 VSS.n257 0.0755
R920 VSS.n257 VSS.n153 0.0755
R921 VSS.n250 VSS.n153 0.0755
R922 VSS.n250 VSS.n249 0.0755
R923 VSS.n249 VSS.n157 0.0755
R924 VSS.n242 VSS.n157 0.0755
R925 VSS.n242 VSS.n241 0.0755
R926 VSS.n241 VSS.n161 0.0755
R927 VSS.n234 VSS.n161 0.0755
R928 VSS.n234 VSS.n233 0.0755
R929 VSS.n233 VSS.n165 0.0755
R930 VSS.n226 VSS.n165 0.0755
R931 VSS.n226 VSS.n225 0.0755
R932 VSS.n225 VSS.n169 0.0755
R933 VSS.n218 VSS.n169 0.0755
R934 VSS.n218 VSS.n217 0.0755
R935 VSS.n217 VSS.n173 0.0755
R936 VSS.n210 VSS.n173 0.0755
R937 VSS.n210 VSS.n209 0.0755
R938 VSS.n209 VSS.n177 0.0755
R939 VSS.n202 VSS.n177 0.0755
R940 VSS.n202 VSS.n201 0.0755
R941 VSS.n201 VSS.n181 0.0755
R942 VSS.n194 VSS.n181 0.0755
R943 VSS.n194 VSS.n193 0.0755
R944 VSS.n193 VSS.n185 0.0755
R945 VSS.n337 VSS.n97 0.0755
R946 VSS.n330 VSS.n97 0.0755
R947 VSS.n330 VSS.n329 0.0755
R948 VSS.n329 VSS.n101 0.0755
R949 VSS.n322 VSS.n101 0.0755
R950 VSS.n322 VSS.n321 0.0755
R951 VSS.n321 VSS.n105 0.0755
R952 VSS.n314 VSS.n105 0.0755
R953 VSS.n314 VSS.n313 0.0755
R954 VSS.n313 VSS.n109 0.0755
R955 VSS.n306 VSS.n109 0.0755
R956 VSS.n306 VSS.n305 0.0755
R957 VSS.n305 VSS.n113 0.0755
R958 VSS.n298 VSS.n113 0.0755
R959 VSS.n298 VSS.n297 0.0755
R960 VSS.n297 VSS.n117 0.0755
R961 VSS.n290 VSS.n117 0.0755
R962 VSS.n290 VSS.n289 0.0755
R963 VSS.n284 VSS.n283 0.0755
R964 VSS.n276 VSS.n275 0.0755
R965 VSS.n334 VSS.n95 0.0755
R966 VSS.n334 VSS.n333 0.0755
R967 VSS.n333 VSS.n99 0.0755
R968 VSS.n326 VSS.n99 0.0755
R969 VSS.n326 VSS.n325 0.0755
R970 VSS.n325 VSS.n103 0.0755
R971 VSS.n318 VSS.n103 0.0755
R972 VSS.n318 VSS.n317 0.0755
R973 VSS.n317 VSS.n107 0.0755
R974 VSS.n310 VSS.n107 0.0755
R975 VSS.n310 VSS.n309 0.0755
R976 VSS.n309 VSS.n111 0.0755
R977 VSS.n302 VSS.n111 0.0755
R978 VSS.n302 VSS.n301 0.0755
R979 VSS.n301 VSS.n115 0.0755
R980 VSS.n294 VSS.n115 0.0755
R981 VSS.n294 VSS.n293 0.0755
R982 VSS.n293 VSS.n119 0.0755
R983 VSS.n286 VSS.n119 0.0755
R984 VSS.n286 VSS.n285 0.0755
R985 VSS.n285 VSS.n122 0.0755
R986 VSS.n125 VSS.n122 0.0755
R987 VSS.n278 VSS.n125 0.0755
R988 VSS.n278 VSS.n277 0.0755
R989 VSS.n277 VSS.n126 0.0755
R990 VSS.n130 VSS.n126 0.0755
R991 VSS.n270 VSS.n130 0.0755
R992 VSS.n270 VSS.n269 0.0755
R993 VSS.n262 VSS.n150 0.0755
R994 VSS.n262 VSS.n261 0.0755
R995 VSS.n261 VSS.n151 0.0755
R996 VSS.n254 VSS.n151 0.0755
R997 VSS.n254 VSS.n253 0.0755
R998 VSS.n253 VSS.n155 0.0755
R999 VSS.n246 VSS.n155 0.0755
R1000 VSS.n246 VSS.n245 0.0755
R1001 VSS.n245 VSS.n159 0.0755
R1002 VSS.n238 VSS.n159 0.0755
R1003 VSS.n238 VSS.n237 0.0755
R1004 VSS.n237 VSS.n163 0.0755
R1005 VSS.n230 VSS.n163 0.0755
R1006 VSS.n230 VSS.n229 0.0755
R1007 VSS.n229 VSS.n167 0.0755
R1008 VSS.n222 VSS.n167 0.0755
R1009 VSS.n222 VSS.n221 0.0755
R1010 VSS.n221 VSS.n171 0.0755
R1011 VSS.n214 VSS.n171 0.0755
R1012 VSS.n214 VSS.n213 0.0755
R1013 VSS.n213 VSS.n175 0.0755
R1014 VSS.n206 VSS.n175 0.0755
R1015 VSS.n206 VSS.n205 0.0755
R1016 VSS.n205 VSS.n179 0.0755
R1017 VSS.n198 VSS.n179 0.0755
R1018 VSS.n198 VSS.n197 0.0755
R1019 VSS.n197 VSS.n183 0.0755
R1020 VSS.n190 VSS.n183 0.0755
R1021 VSS.n190 VSS.n189 0.0755
R1022 VSS.n452 VSS.n451 0.0755
R1023 VSS.n452 VSS.n91 0.0755
R1024 VSS.n460 VSS.n91 0.0755
R1025 VSS.n461 VSS.n460 0.0755
R1026 VSS.n461 VSS.n89 0.0755
R1027 VSS.n466 VSS.n89 0.0755
R1028 VSS.n467 VSS.n466 0.0755
R1029 VSS.n467 VSS.n85 0.0755
R1030 VSS.n474 VSS.n85 0.0755
R1031 VSS.n476 VSS.n81 0.0755
R1032 VSS.n483 VSS.n81 0.0755
R1033 VSS.n485 VSS.n483 0.0755
R1034 VSS.n485 VSS.n484 0.0755
R1035 VSS.n494 VSS.n73 0.0755
R1036 VSS.n501 VSS.n73 0.0755
R1037 VSS.n502 VSS.n501 0.0755
R1038 VSS.n502 VSS.n70 0.0755
R1039 VSS.n508 VSS.n70 0.0755
R1040 VSS.n510 VSS.n65 0.0755
R1041 VSS.n517 VSS.n65 0.0755
R1042 VSS.n518 VSS.n517 0.0755
R1043 VSS.n518 VSS.n60 0.0755
R1044 VSS.n527 VSS.n44 0.0755
R1045 VSS.n640 VSS.n45 0.0755
R1046 VSS.n633 VSS.n45 0.0755
R1047 VSS.n633 VSS.n632 0.0755
R1048 VSS.n625 VSS.n55 0.0755
R1049 VSS.n625 VSS.n624 0.0755
R1050 VSS.n624 VSS.n56 0.0755
R1051 VSS.n617 VSS.n56 0.0755
R1052 VSS.n608 VSS.n535 0.0755
R1053 VSS.n608 VSS.n607 0.0755
R1054 VSS.n607 VSS.n536 0.0755
R1055 VSS.n602 VSS.n536 0.0755
R1056 VSS.n602 VSS.n601 0.0755
R1057 VSS.n601 VSS.n539 0.0755
R1058 VSS.n594 VSS.n539 0.0755
R1059 VSS.n594 VSS.n593 0.0755
R1060 VSS.n593 VSS.n543 0.0755
R1061 VSS.n586 VSS.n543 0.0755
R1062 VSS.n584 VSS.n548 0.0755
R1063 VSS.n577 VSS.n548 0.0755
R1064 VSS.n577 VSS.n576 0.0755
R1065 VSS.n576 VSS.n552 0.0755
R1066 VSS.n569 VSS.n552 0.0755
R1067 VSS.n569 VSS.n568 0.0755
R1068 VSS.n568 VSS.n557 0.0755
R1069 VSS.n562 VSS.n557 0.0755
R1070 VSS.n562 VSS.n561 0.0755
R1071 VSS.n561 VSS.n560 0.0755
R1072 VSS.n463 VSS.n462 0.0755
R1073 VSS.n604 VSS.n603 0.0755
R1074 VSS.n563 VSS.n559 0.0755
R1075 VSS.n559 VSS.n0 0.0755
R1076 VSS.n729 VSS.n3 0.07175
R1077 VSS.n410 VSS.n359 0.068
R1078 VSS.n409 VSS.n360 0.068
R1079 VSS.n406 VSS.n405 0.068
R1080 VSS.n402 VSS.n362 0.068
R1081 VSS.n401 VSS.n365 0.068
R1082 VSS.n399 VSS.n398 0.068
R1083 VSS.n484 VSS.n77 0.068
R1084 VSS.n465 VSS.n464 0.068
R1085 VSS.n468 VSS.n88 0.068
R1086 VSS.n469 VSS.n86 0.068
R1087 VSS.n473 VSS.n472 0.068
R1088 VSS.n477 VSS.n84 0.068
R1089 VSS.n478 VSS.n82 0.068
R1090 VSS.n482 VSS.n481 0.068
R1091 VSS.n486 VSS.n80 0.068
R1092 VSS.n487 VSS.n78 0.068
R1093 VSS.n491 VSS.n490 0.068
R1094 VSS.n495 VSS.n76 0.068
R1095 VSS.n496 VSS.n74 0.068
R1096 VSS.n500 VSS.n499 0.068
R1097 VSS.n503 VSS.n72 0.068
R1098 VSS.n338 VSS.n96 0.0665
R1099 VSS.n336 VSS.n335 0.0665
R1100 VSS.n332 VSS.n98 0.0665
R1101 VSS.n331 VSS.n100 0.0665
R1102 VSS.n328 VSS.n327 0.0665
R1103 VSS.n324 VSS.n102 0.0665
R1104 VSS.n323 VSS.n104 0.0665
R1105 VSS.n320 VSS.n319 0.0665
R1106 VSS.n316 VSS.n106 0.0665
R1107 VSS.n315 VSS.n108 0.0665
R1108 VSS.n312 VSS.n311 0.0665
R1109 VSS.n308 VSS.n110 0.0665
R1110 VSS.n307 VSS.n112 0.0665
R1111 VSS.n304 VSS.n303 0.0665
R1112 VSS.n300 VSS.n114 0.0665
R1113 VSS.n299 VSS.n116 0.0665
R1114 VSS.n296 VSS.n295 0.0665
R1115 VSS.n292 VSS.n118 0.0665
R1116 VSS.n291 VSS.n120 0.0665
R1117 VSS.n288 VSS.n287 0.0665
R1118 VSS.n284 VSS.n121 0.0665
R1119 VSS.n371 VSS.n368 0.0605
R1120 VSS.n664 VSS.n663 0.0605
R1121 VSS.n393 VSS.n369 0.0605
R1122 VSS.n391 VSS.n390 0.0605
R1123 VSS.n387 VSS.n370 0.0605
R1124 VSS.n282 VSS.n123 0.0605
R1125 VSS.n280 VSS.n279 0.0605
R1126 VSS.n276 VSS.n124 0.0605
R1127 VSS.n510 VSS.n509 0.0605
R1128 VSS.n55 VSS.n51 0.0605
R1129 VSS.n413 VSS.n356 0.0595625
R1130 VSS VSS.n0 0.054875
R1131 VSS.n382 VSS.n377 0.0535625
R1132 VSS.n363 VSS.n358 0.053
R1133 VSS.n668 VSS.n667 0.053
R1134 VSS.n493 VSS.n492 0.053
R1135 VSS.n528 VSS.n60 0.053
R1136 VSS.n617 VSS.n616 0.053
R1137 VSS.n274 VSS.n127 0.04925
R1138 VSS.n272 VSS.n271 0.04925
R1139 VSS.n268 VSS.n129 0.04925
R1140 VSS.n267 VSS.n147 0.04925
R1141 VSS.n264 VSS.n263 0.04925
R1142 VSS.n260 VSS.n149 0.04925
R1143 VSS.n259 VSS.n152 0.04925
R1144 VSS.n256 VSS.n255 0.04925
R1145 VSS.n252 VSS.n154 0.04925
R1146 VSS.n251 VSS.n156 0.04925
R1147 VSS.n248 VSS.n247 0.04925
R1148 VSS.n244 VSS.n158 0.04925
R1149 VSS.n243 VSS.n160 0.04925
R1150 VSS.n240 VSS.n239 0.04925
R1151 VSS.n236 VSS.n162 0.04925
R1152 VSS.n235 VSS.n164 0.04925
R1153 VSS.n232 VSS.n231 0.04925
R1154 VSS.n228 VSS.n166 0.04925
R1155 VSS.n227 VSS.n168 0.04925
R1156 VSS.n224 VSS.n223 0.04925
R1157 VSS.n220 VSS.n170 0.04925
R1158 VSS.n219 VSS.n172 0.04925
R1159 VSS.n216 VSS.n215 0.04925
R1160 VSS.n212 VSS.n174 0.04925
R1161 VSS.n211 VSS.n176 0.04925
R1162 VSS.n208 VSS.n207 0.04925
R1163 VSS.n204 VSS.n178 0.04925
R1164 VSS.n203 VSS.n180 0.04925
R1165 VSS.n200 VSS.n199 0.04925
R1166 VSS.n196 VSS.n182 0.04925
R1167 VSS.n195 VSS.n184 0.04925
R1168 VSS.n192 VSS.n191 0.04925
R1169 VSS.n188 VSS.n186 0.04925
R1170 VSS.n435 VSS.n347 0.0485
R1171 VSS.n432 VSS.n431 0.0485
R1172 VSS.n428 VSS.n349 0.0485
R1173 VSS.n427 VSS.n351 0.0485
R1174 VSS.n424 VSS.n423 0.0485
R1175 VSS.n420 VSS.n353 0.0485
R1176 VSS.n419 VSS.n355 0.0485
R1177 VSS.n416 VSS.n415 0.0485
R1178 VSS.n387 VSS.n386 0.047
R1179 VSS.n384 VSS.n373 0.047
R1180 VSS.n383 VSS.n376 0.047
R1181 VSS.n375 VSS.n41 0.047
R1182 VSS.n367 VSS.n364 0.045875
R1183 VSS.n445 VSS.n341 0.045875
R1184 VSS.n443 VSS.n442 0.045875
R1185 VSS.n439 VSS.n343 0.045875
R1186 VSS.n438 VSS.n346 0.045875
R1187 VSS.n436 VSS.n435 0.045875
R1188 VSS.n450 VSS.n449 0.045875
R1189 VSS.n453 VSS.n94 0.045875
R1190 VSS.n455 VSS.n454 0.045875
R1191 VSS.n459 VSS.n92 0.045875
R1192 VSS.n476 VSS.n475 0.0455
R1193 VSS.n458 VSS.n90 0.0455
R1194 VSS.n648 VSS.n647 0.044
R1195 VSS.n651 VSS.n39 0.044
R1196 VSS.n653 VSS.n652 0.044
R1197 VSS.n662 VSS.n36 0.044
R1198 VSS.n661 VSS.n37 0.044
R1199 VSS.n659 VSS.n658 0.044
R1200 VSS.n656 VSS.n32 0.0425
R1201 VSS.n670 VSS.n669 0.0425
R1202 VSS.n673 VSS.n31 0.0425
R1203 VSS.n674 VSS.n29 0.0425
R1204 VSS.n679 VSS.n678 0.0425
R1205 VSS.n681 VSS.n27 0.0425
R1206 VSS.n504 VSS.n503 0.0425
R1207 VSS.n506 VSS.n71 0.0425
R1208 VSS.n507 VSS.n68 0.0425
R1209 VSS.n512 VSS.n511 0.0425
R1210 VSS.n515 VSS.n66 0.0425
R1211 VSS.n516 VSS.n64 0.0425
R1212 VSS.n521 VSS.n519 0.0425
R1213 VSS.n520 VSS.n61 0.0425
R1214 VSS.n526 VSS.n525 0.0425
R1215 VSS.n62 VSS.n46 0.0425
R1216 VSS.n639 VSS.n638 0.0425
R1217 VSS.n635 VSS.n47 0.0425
R1218 VSS.n634 VSS.n50 0.0425
R1219 VSS.n631 VSS.n630 0.0425
R1220 VSS.n627 VSS.n52 0.0425
R1221 VSS.n626 VSS.n54 0.0425
R1222 VSS.n623 VSS.n622 0.0425
R1223 VSS.n619 VSS.n57 0.0425
R1224 VSS.n618 VSS.n59 0.0425
R1225 VSS.n614 VSS.n613 0.0425
R1226 VSS.n610 VSS.n532 0.0425
R1227 VSS.n609 VSS.n534 0.0425
R1228 VSS.n606 VSS.n605 0.0425
R1229 VSS.n382 VSS.n381 0.0423125
R1230 VSS.n683 VSS.n24 0.041
R1231 VSS.n687 VSS.n686 0.041
R1232 VSS.n690 VSS.n23 0.041
R1233 VSS.n691 VSS.n21 0.041
R1234 VSS.n695 VSS.n694 0.041
R1235 VSS.n698 VSS.n19 0.041
R1236 VSS.n699 VSS.n16 0.041
R1237 VSS.n704 VSS.n703 0.041
R1238 VSS.n707 VSS.n14 0.041
R1239 VSS.n708 VSS.n12 0.041
R1240 VSS.n712 VSS.n711 0.041
R1241 VSS.n715 VSS.n10 0.041
R1242 VSS.n716 VSS.n7 0.041
R1243 VSS.n721 VSS.n720 0.041
R1244 VSS.n723 VSS.n5 0.041
R1245 VSS.n603 VSS.n537 0.041
R1246 VSS.n600 VSS.n599 0.041
R1247 VSS.n596 VSS.n540 0.041
R1248 VSS.n595 VSS.n542 0.041
R1249 VSS.n592 VSS.n591 0.041
R1250 VSS.n588 VSS.n544 0.041
R1251 VSS.n587 VSS.n546 0.041
R1252 VSS.n583 VSS.n582 0.041
R1253 VSS.n579 VSS.n549 0.041
R1254 VSS.n578 VSS.n551 0.041
R1255 VSS.n575 VSS.n574 0.041
R1256 VSS.n571 VSS.n553 0.041
R1257 VSS.n570 VSS.n555 0.041
R1258 VSS.n567 VSS.n566 0.041
R1259 VSS.n564 VSS.n558 0.041
R1260 VSS.n644 VSS.n643 0.040625
R1261 VSS.n269 VSS.n146 0.040625
R1262 VSS.n641 VSS.n44 0.040625
R1263 VSS.n643 VSS.n642 0.0381812
R1264 VSS.n642 VSS.n641 0.0381812
R1265 VSS.n666 VSS.n30 0.038
R1266 VSS.n675 VSS.n30 0.038
R1267 VSS.n701 VSS.n700 0.038
R1268 VSS.n702 VSS.n701 0.038
R1269 VSS.n728 VSS.n727 0.038
R1270 VSS.n615 VSS.n531 0.038
R1271 VSS.n535 VSS.n531 0.038
R1272 VSS.n586 VSS.n585 0.038
R1273 VSS.n585 VSS.n584 0.038
R1274 VSS.n560 VSS.n1 0.038
R1275 VSS.n344 VSS.n340 0.0378125
R1276 VSS.n643 VSS.n40 0.035375
R1277 VSS.n150 VSS.n146 0.035375
R1278 VSS.n641 VSS.n640 0.035375
R1279 VSS.n686 VSS.n24 0.035
R1280 VSS.n687 VSS.n23 0.035
R1281 VSS.n691 VSS.n690 0.035
R1282 VSS.n694 VSS.n21 0.035
R1283 VSS.n695 VSS.n19 0.035
R1284 VSS.n699 VSS.n698 0.035
R1285 VSS.n703 VSS.n16 0.035
R1286 VSS.n704 VSS.n14 0.035
R1287 VSS.n708 VSS.n707 0.035
R1288 VSS.n711 VSS.n12 0.035
R1289 VSS.n712 VSS.n10 0.035
R1290 VSS.n716 VSS.n715 0.035
R1291 VSS.n720 VSS.n7 0.035
R1292 VSS.n721 VSS.n5 0.035
R1293 VSS.n724 VSS.n723 0.035
R1294 VSS.n600 VSS.n537 0.035
R1295 VSS.n599 VSS.n540 0.035
R1296 VSS.n596 VSS.n595 0.035
R1297 VSS.n592 VSS.n542 0.035
R1298 VSS.n591 VSS.n544 0.035
R1299 VSS.n588 VSS.n587 0.035
R1300 VSS.n583 VSS.n546 0.035
R1301 VSS.n582 VSS.n549 0.035
R1302 VSS.n579 VSS.n578 0.035
R1303 VSS.n575 VSS.n551 0.035
R1304 VSS.n574 VSS.n553 0.035
R1305 VSS.n571 VSS.n570 0.035
R1306 VSS.n567 VSS.n555 0.035
R1307 VSS.n566 VSS.n558 0.035
R1308 VSS.n564 VSS.n563 0.035
R1309 VSS.n669 VSS.n32 0.0335
R1310 VSS.n670 VSS.n31 0.0335
R1311 VSS.n674 VSS.n673 0.0335
R1312 VSS.n678 VSS.n29 0.0335
R1313 VSS.n679 VSS.n27 0.0335
R1314 VSS.n682 VSS.n681 0.0335
R1315 VSS.n504 VSS.n71 0.0335
R1316 VSS.n507 VSS.n506 0.0335
R1317 VSS.n511 VSS.n68 0.0335
R1318 VSS.n512 VSS.n66 0.0335
R1319 VSS.n516 VSS.n515 0.0335
R1320 VSS.n519 VSS.n64 0.0335
R1321 VSS.n521 VSS.n520 0.0335
R1322 VSS.n526 VSS.n61 0.0335
R1323 VSS.n525 VSS.n62 0.0335
R1324 VSS.n639 VSS.n46 0.0335
R1325 VSS.n638 VSS.n47 0.0335
R1326 VSS.n635 VSS.n634 0.0335
R1327 VSS.n631 VSS.n50 0.0335
R1328 VSS.n630 VSS.n52 0.0335
R1329 VSS.n627 VSS.n626 0.0335
R1330 VSS.n623 VSS.n54 0.0335
R1331 VSS.n622 VSS.n57 0.0335
R1332 VSS.n619 VSS.n618 0.0335
R1333 VSS.n614 VSS.n59 0.0335
R1334 VSS.n613 VSS.n532 0.0335
R1335 VSS.n610 VSS.n609 0.0335
R1336 VSS.n606 VSS.n534 0.0335
R1337 VSS.n605 VSS.n604 0.0335
R1338 VSS.n647 VSS.n646 0.032
R1339 VSS.n648 VSS.n39 0.032
R1340 VSS.n653 VSS.n651 0.032
R1341 VSS.n652 VSS.n36 0.032
R1342 VSS.n662 VSS.n661 0.032
R1343 VSS.n659 VSS.n37 0.032
R1344 VSS.n475 VSS.n474 0.0305
R1345 VSS.n397 VSS.n367 0.030125
R1346 VSS.n443 VSS.n341 0.030125
R1347 VSS.n442 VSS.n343 0.030125
R1348 VSS.n439 VSS.n438 0.030125
R1349 VSS.n436 VSS.n346 0.030125
R1350 VSS.n450 VSS.n94 0.030125
R1351 VSS.n455 VSS.n453 0.030125
R1352 VSS.n454 VSS.n92 0.030125
R1353 VSS.n459 VSS.n458 0.030125
R1354 VSS.n386 VSS.n373 0.029
R1355 VSS.n384 VSS.n383 0.029
R1356 VSS.n376 VSS.n375 0.029
R1357 VSS.n645 VSS.n41 0.029
R1358 VSS.n432 VSS.n347 0.0275
R1359 VSS.n431 VSS.n349 0.0275
R1360 VSS.n428 VSS.n427 0.0275
R1361 VSS.n424 VSS.n351 0.0275
R1362 VSS.n423 VSS.n353 0.0275
R1363 VSS.n420 VSS.n419 0.0275
R1364 VSS.n416 VSS.n355 0.0275
R1365 VSS.n415 VSS.n414 0.0275
R1366 VSS.n275 VSS.n274 0.02675
R1367 VSS.n272 VSS.n127 0.02675
R1368 VSS.n271 VSS.n129 0.02675
R1369 VSS.n268 VSS.n267 0.02675
R1370 VSS.n264 VSS.n147 0.02675
R1371 VSS.n263 VSS.n149 0.02675
R1372 VSS.n260 VSS.n259 0.02675
R1373 VSS.n256 VSS.n152 0.02675
R1374 VSS.n255 VSS.n154 0.02675
R1375 VSS.n252 VSS.n251 0.02675
R1376 VSS.n248 VSS.n156 0.02675
R1377 VSS.n247 VSS.n158 0.02675
R1378 VSS.n244 VSS.n243 0.02675
R1379 VSS.n240 VSS.n160 0.02675
R1380 VSS.n239 VSS.n162 0.02675
R1381 VSS.n236 VSS.n235 0.02675
R1382 VSS.n232 VSS.n164 0.02675
R1383 VSS.n231 VSS.n166 0.02675
R1384 VSS.n228 VSS.n227 0.02675
R1385 VSS.n224 VSS.n168 0.02675
R1386 VSS.n223 VSS.n170 0.02675
R1387 VSS.n220 VSS.n219 0.02675
R1388 VSS.n216 VSS.n172 0.02675
R1389 VSS.n215 VSS.n174 0.02675
R1390 VSS.n212 VSS.n211 0.02675
R1391 VSS.n208 VSS.n176 0.02675
R1392 VSS.n207 VSS.n178 0.02675
R1393 VSS.n204 VSS.n203 0.02675
R1394 VSS.n200 VSS.n180 0.02675
R1395 VSS.n199 VSS.n182 0.02675
R1396 VSS.n196 VSS.n195 0.02675
R1397 VSS.n192 VSS.n184 0.02675
R1398 VSS.n191 VSS.n186 0.02675
R1399 VSS.n188 VSS.n187 0.02675
R1400 VSS.n404 VSS.n363 0.023
R1401 VSS.n380 VSS.n42 0.023
R1402 VSS.n667 VSS.n666 0.023
R1403 VSS.n494 VSS.n493 0.023
R1404 VSS.n528 VSS.n527 0.023
R1405 VSS.n616 VSS.n615 0.023
R1406 VSS.n377 VSS.n372 0.0224375
R1407 VSS VSS.n731 0.017375
R1408 VSS.n417 VSS.n356 0.0164375
R1409 VSS.n395 VSS.n368 0.0155
R1410 VSS.n664 VSS.n34 0.0155
R1411 VSS.n394 VSS.n393 0.0155
R1412 VSS.n391 VSS.n369 0.0155
R1413 VSS.n390 VSS.n370 0.0155
R1414 VSS.n283 VSS.n282 0.0155
R1415 VSS.n280 VSS.n123 0.0155
R1416 VSS.n279 VSS.n124 0.0155
R1417 VSS.n509 VSS.n508 0.0155
R1418 VSS.n632 VSS.n51 0.0155
R1419 VSS.n381 VSS.n380 0.0111875
R1420 VSS.n336 VSS.n96 0.0095
R1421 VSS.n335 VSS.n98 0.0095
R1422 VSS.n332 VSS.n331 0.0095
R1423 VSS.n328 VSS.n100 0.0095
R1424 VSS.n327 VSS.n102 0.0095
R1425 VSS.n324 VSS.n323 0.0095
R1426 VSS.n320 VSS.n104 0.0095
R1427 VSS.n319 VSS.n106 0.0095
R1428 VSS.n316 VSS.n315 0.0095
R1429 VSS.n312 VSS.n108 0.0095
R1430 VSS.n311 VSS.n110 0.0095
R1431 VSS.n308 VSS.n307 0.0095
R1432 VSS.n304 VSS.n112 0.0095
R1433 VSS.n303 VSS.n114 0.0095
R1434 VSS.n300 VSS.n299 0.0095
R1435 VSS.n296 VSS.n116 0.0095
R1436 VSS.n295 VSS.n118 0.0095
R1437 VSS.n292 VSS.n291 0.0095
R1438 VSS.n288 VSS.n120 0.0095
R1439 VSS.n287 VSS.n121 0.0095
R1440 VSS.n359 VSS.n357 0.008
R1441 VSS.n410 VSS.n409 0.008
R1442 VSS.n406 VSS.n360 0.008
R1443 VSS.n405 VSS.n362 0.008
R1444 VSS.n402 VSS.n401 0.008
R1445 VSS.n399 VSS.n365 0.008
R1446 VSS.n492 VSS.n77 0.008
R1447 VSS.n464 VSS.n463 0.008
R1448 VSS.n465 VSS.n88 0.008
R1449 VSS.n469 VSS.n468 0.008
R1450 VSS.n472 VSS.n86 0.008
R1451 VSS.n473 VSS.n84 0.008
R1452 VSS.n478 VSS.n477 0.008
R1453 VSS.n481 VSS.n82 0.008
R1454 VSS.n482 VSS.n80 0.008
R1455 VSS.n487 VSS.n486 0.008
R1456 VSS.n490 VSS.n78 0.008
R1457 VSS.n491 VSS.n76 0.008
R1458 VSS.n496 VSS.n495 0.008
R1459 VSS.n499 VSS.n74 0.008
R1460 VSS.n500 VSS.n72 0.008
R1461 VSS.n462 VSS.n90 0.000875
C0 o2n mRp2b 0.00107f
C1 g3n outn 0.10389f
C2 VDD vb 5.56728f
C3 vgr nb 0.68599f
C4 t2 outn 1.43221f
C5 vb mRp2b 0.57255f
C6 o1p g2p 4.53819f
C7 vgr t1 0.02393f
C8 outn g3p 3.04668f
C9 g2p outn 0.2394f
C10 g2n t2 2.93218f
C11 g2n g3p 0.00924f
C12 g2n g2p 4.72021f
C13 enb t1 0.21873f
C14 g3n o2p 0.19553f
C15 VDD inp 0.37885f
C16 vbt t1 0.00159f
C17 VDD mRp2b 1.27896f
C18 enb inn 0.32081f
C19 mRp2a vb 3.04322f
C20 t2 o2p 0.3005f
C21 g2p o1n 2.57561f
C22 o2p g3p 5.93947f
C23 o2p g2p 2.6676f
C24 vbt inn 0.00951f
C25 g3n mRp3a 0.1479f
C26 g3n nb 0.25688f
C27 VDD mRp2a 0.04832f
C28 o1p o2n 0.0821f
C29 outp outn 5.22512f
C30 o2n outn 1.61543f
C31 mRp3a g3p 2.77518f
C32 g2n outp 0.06647f
C33 g2n o2n 0.63341f
C34 g3n t3 2.927f
C35 mRp2a mRp2b 0.14576f
C36 t2 nb 3.14973f
C37 vgr vbt 0.08774f
C38 nb g3p 0.26793f
C39 nb g2p 0.24468f
C40 o1p vb 0.14015f
C41 vb outn 0.35632f
C42 t2 t1 0.003f
C43 t2 t3 0.00372f
C44 g2n vb 0.51815f
C45 t3 g3p 2.91775f
C46 g2p t1 0.01213f
C47 enb vbt 0.62326f
C48 o2n o1n 0.38655f
C49 outp o2p 0.29088f
C50 o2p o2n 4.93961f
C51 g2p inn 0.02671f
C52 o1p VDD 1.62523f
C53 mRp3a mRp3b 0.08704f
C54 VDD outn 0.81057f
C55 g2n VDD 1.86961f
C56 o1p inp 0.43338f
C57 vb o1n 0.18862f
C58 inp outn 0.01544f
C59 o2p vb 1.28732f
C60 g3n vgr 0.06347f
C61 g2n inp 0.02054f
C62 g2n mRp2b 0.62129f
C63 outp mRp3a 2.19053f
C64 vgr t2 0
C65 vgr g3p 0.17578f
C66 vgr g2p 0.18791f
C67 outp nb 3.09056f
C68 nb o2n 0.76234f
C69 VDD o1n 1.55489f
C70 mRp3a vb 0.68743f
C71 VDD o2p 2.4401f
C72 o2n t1 0.48826f
C73 outp t3 0.49739f
C74 t3 o2n 0.30481f
C75 inp o1n 9.18763f
C76 enb g2p 0.00127f
C77 nb vb 0.24004f
C78 o2p inp 1.07262f
C79 o2p mRp2b 0.58102f
C80 g2n mRp2a 0.13427f
C81 vbt g2p 1.35765f
C82 inn o2n 0.99043f
C83 t3 vb 0.15494f
C84 mRp3a VDD 0.1197f
C85 vgr mRp3b 0.0027f
C86 VDD nb 0.01462f
C87 mRp2a o1n 0.04266f
C88 o2p mRp2a 0.02666f
C89 nb inp 0
C90 VDD t1 0.46805f
C91 vgr outp 0.11983f
C92 vgr o2n 1.36404f
C93 o1p outn 0.00139f
C94 g3n t2 0
C95 inp t1 15.0186f
C96 o1p g2n 0.02964f
C97 g3n g3p 0.34872f
C98 g2n outn 0.18234f
C99 VDD inn 0.09959f
C100 vgr vb 8.80617f
C101 enb o2n 0.78638f
C102 inp inn 5.36931f
C103 t2 g3p 0.01189f
C104 t2 g2p 2.90297f
C105 g2p g3p 0.01549f
C106 o1p o1n 6.02565f
C107 outn o1n 0.01468f
C108 o1p o2p 0.17851f
C109 o2p outn 1.57379f
C110 vbt vb 0.28747f
C111 g2n o1n 6.65711f
C112 vgr VDD 8.32479f
C113 g2n o2p 4.3121f
C114 g3n mRp3b 0.50302f
C115 vgr inp 0.00265f
C116 vgr mRp2b 0.00978f
C117 enb VDD 4.21057f
C118 mRp3b g3p 0.14588f
C119 mRp3a outn 0.00909f
C120 g3n outp 3.27704f
C121 g3n o2n 6.81759f
C122 vbt VDD 1.66707f
C123 enb inp 0.39919f
C124 o1p nb 0
C125 o2p o1n 0.37415f
C126 nb outn 4.9308f
C127 vbt inp 0.00152f
C128 g2n nb 0.24448f
C129 outp t2 0.45205f
C130 t2 o2n 0.56895f
C131 outp g3p 1.06878f
C132 g3n vb 0.62722f
C133 o1p t1 10.4824f
C134 o2n g3p 0.12772f
C135 outp g2p 0.10829f
C136 g2p o2n 3.24823f
C137 outn t1 0.03767f
C138 vgr mRp2a 0.05312f
C139 t3 outn 0.87498f
C140 g2n t1 0.01151f
C141 o1p inn 15.6107f
C142 vb g3p 0.84842f
C143 inn outn 0.01688f
C144 g2p vb 0.66867f
C145 mRp3a o2p 0.03426f
C146 g2n inn 0.02783f
C147 nb o1n 0.2255f
C148 g3n VDD 3.99802f
C149 o2p nb 0.12272f
C150 vbt mRp2a 0.00601f
C151 t1 o1n 10.8992f
C152 o2p t1 0.41474f
C153 t3 o2p 0
C154 outp mRp3b 1.22474f
C155 VDD g3p 4.33045f
C156 VDD g2p 2.40668f
C157 o1p vgr 0.31673f
C158 vgr outn 2.4529f
C159 inn o1n 0.54853f
C160 o2p inn 1.11701f
C161 g2p inp 0.01844f
C162 g2n vgr 1.61644f
C163 g2p mRp2b 0.62517f
C164 mRp3b vb 0.42363f
C165 outp o2n 2.5434f
C166 o1p enb 0.20141f
C167 o1p vbt 1.6832f
C168 nb t1 3.7328f
C169 t3 nb 3.13673f
C170 outp vb 1.63881f
C171 vb o2n 0.349f
C172 vgr o1n 2.75167f
C173 VDD mRp3b 0.14807f
C174 vgr o2p 0.2326f
C175 g2p mRp2a 2.71538f
C176 nb inn 0
C177 inn t1 15.1293f
C178 enb o1n 0.32203f
C179 enb o2p 0.79409f
C180 outp VDD 0.82022f
C181 VDD o2n 1.98856f
C182 vbt o1n 1.19688f
C183 vgr mRp3a 0.05207f
C184 inp o2n 1.03194f
C185 nb VSS 9.97817f
C186 inn VSS 2.38457f
C187 inp VSS 2.67259f
C188 enb VSS 2.72347f
C189 outp VSS 13.8188f
C190 outn VSS 13.9469f
C191 VDD VSS 57.2976f
C192 t3 VSS 2.7495f
C193 t2 VSS 2.36151f
C194 t1 VSS 5.22957f
C195 mRp3b VSS 0.70445f
C196 mRp3a VSS 0.87833f
C197 mRp2b VSS 0.92869f
C198 mRp2a VSS 0.74262f
C199 vgr VSS 7.75341f
C200 vbt VSS 1.69087f
C201 o2n VSS 68.4091f
C202 o2p VSS 65.7776f
C203 o1n VSS 47.9574f
C204 o1p VSS 42.8538f
C205 g3n VSS 8.44603f
C206 g3p VSS 7.0443f
C207 g2n VSS 7.99495f
C208 g2p VSS 8.02654f
C209 vb VSS 63.9908f
C210 VDD.n0 VSS 0.148002f
C211 VDD.t1 VSS 0.0813299f
C212 VDD.n1 VSS 0.263118f
C213 VDD.n2 VSS 0.131559f
C214 VDD.n3 VSS 0.143968f
C215 VDD.n4 VSS 0.263118f
C216 VDD.n5 VSS 0.160503f
C217 VDD.n6 VSS 0.263118f
C218 VDD.n7 VSS 0.131559f
C219 VDD.n8 VSS 0.263118f
C220 VDD.n9 VSS 0.131559f
C221 VDD.n10 VSS 0.263118f
C222 VDD.n11 VSS 0.131559f
C223 VDD.n12 VSS 0.696642f
C224 VDD.n13 VSS 0.131559f
C225 VDD.n14 VSS 0.263118f
C226 VDD.n15 VSS 0.142083f
C227 VDD.n16 VSS 0.263118f
C228 VDD.n17 VSS 0.131559f
C229 VDD.n18 VSS 0.263118f
C230 VDD.n19 VSS 0.131559f
C231 VDD.n20 VSS 0.263118f
C232 VDD.n21 VSS 0.131559f
C233 VDD.n22 VSS 0.0727246f
C234 VDD.n23 VSS 0.263118f
C235 VDD.n24 VSS 0.131559f
C236 VDD.n25 VSS 0.263118f
C237 VDD.n26 VSS 0.131559f
C238 VDD.n27 VSS 0.263118f
C239 VDD.n28 VSS 0.131559f
C240 VDD.n29 VSS 4.23554f
C241 VDD.t0 VSS 4.59703f
C242 VDD.n30 VSS 9.85397f
C243 VDD.n31 VSS 0.31266f
C244 VDD.n32 VSS 0.131559f
C245 VDD.n33 VSS 0.131559f
C246 VDD.n34 VSS 0.601415f
C247 VDD.n35 VSS 0.263118f
C248 VDD.n36 VSS 0.131559f
C249 VDD.n37 VSS 0.131559f
C250 VDD.n38 VSS 0.263118f
C251 VDD.n39 VSS 0.263118f
C252 VDD.n40 VSS 0.131559f
C253 VDD.n41 VSS 0.131559f
C254 VDD.n42 VSS 0.451065f
C255 VDD.n43 VSS 0.140958f
C256 VDD.n44 VSS 0.207869f
C257 VDD.n45 VSS 0.263118f
C258 VDD.n46 VSS 0.263118f
C259 VDD.n47 VSS 0.263118f
C260 VDD.n48 VSS 0.0904048f
C261 VDD.n49 VSS 0.144212f
C262 VDD.n50 VSS 0.516216f
C263 VDD.n51 VSS 0.131559f
C264 VDD.n52 VSS 0.131559f
C265 VDD.n53 VSS 0.263118f
C266 VDD.n54 VSS 0.263118f
C267 VDD.n55 VSS 0.131559f
C268 VDD.n56 VSS 0.131559f
C269 VDD.n57 VSS 0.131559f
C270 VDD.n58 VSS 0.263118f
C271 VDD.n59 VSS 0.451065f
C272 VDD.n60 VSS 0.140958f
C273 VDD.n61 VSS 0.131559f
C274 VDD.n62 VSS 0.263118f
C275 VDD.n63 VSS 0.263118f
C276 VDD.n64 VSS 0.263118f
C277 VDD.n65 VSS 0.263118f
C278 VDD.n66 VSS 0.234181f
C279 VDD.n67 VSS 0.153234f
C280 VDD.n68 VSS 0.131559f
C281 VDD.n69 VSS 0.263118f
C282 VDD.n70 VSS 0.263118f
C283 VDD.n71 VSS 0.131559f
C284 VDD.n72 VSS 0.131559f
C285 VDD.n73 VSS 0.263118f
C286 VDD.n74 VSS 0.263118f
C287 VDD.n75 VSS 0.131559f
C288 VDD.n76 VSS 0.131559f
C289 VDD.n77 VSS 0.263118f
C290 VDD.n78 VSS 0.263118f
C291 VDD.n79 VSS 0.131559f
C292 VDD.n80 VSS 0.131559f
C293 VDD.n81 VSS 0.131559f
C294 VDD.n82 VSS 0.263118f
C295 VDD.n83 VSS 0.451065f
C296 VDD.n84 VSS 0.140958f
C297 VDD.n85 VSS 0.131559f
C298 VDD.n86 VSS 0.263118f
C299 VDD.n87 VSS 0.263118f
C300 VDD.n88 VSS 0.263118f
C301 VDD.n89 VSS 0.263118f
C302 VDD.n90 VSS 0.0238182f
C303 VDD.t5 VSS 0.0969662f
C304 VDD.t7 VSS 0.0418158f
C305 VDD.n91 VSS 0.554784f
C306 VDD.t2 VSS 0.0418158f
C307 VDD.n92 VSS 0.394638f
C308 VDD.t3 VSS 0.0418158f
C309 VDD.n93 VSS 0.757712f
C310 VDD.t6 VSS 0.145271f
C311 VDD.n94 VSS 0.739741f
C312 VDD.t4 VSS 0.145271f
C313 VDD.n95 VSS 0.310999f
C314 VDD.n96 VSS 0.189534f
C315 VDD.n97 VSS 0.110512f
C316 VDD.n98 VSS 0.263118f
C317 VDD.n99 VSS 0.263118f
C318 VDD.n100 VSS 0.131559f
C319 VDD.n101 VSS 0.131559f
C320 VDD.n102 VSS 0.131559f
C321 VDD.n103 VSS 0.511209f
C322 VDD.n104 VSS -14.6122f
C323 VDD.n105 VSS -0.340175f
C324 VDD.n106 VSS 0.131559f
C325 VDD.n107 VSS 0.263118f
C326 VDD.n108 VSS 0.218061f
C327 VDD.n109 VSS 0.457309f
C328 outn.t3 VSS 2.49574f
C329 outn.t6 VSS 2.49668f
C330 outn.t5 VSS 2.46117f
C331 outn.n0 VSS 0.644842f
C332 outn.t4 VSS 2.46117f
C333 outn.n1 VSS 0.323033f
C334 outn.n2 VSS 0.402899f
C335 outn.t1 VSS 0.111771f
C336 outn.t0 VSS 0.103905f
C337 outn.n3 VSS 0.104536f
C338 outn.n4 VSS 0.217633f
C339 outn.t2 VSS 0.0105024f
C340 outn.n5 VSS 0.131354f
C341 outp.t3 VSS 2.46307f
C342 outp.t6 VSS 2.48886f
C343 outp.t5 VSS 2.45505f
C344 outp.n0 VSS 0.640836f
C345 outp.t4 VSS 2.45505f
C346 outp.n1 VSS 0.337366f
C347 outp.n2 VSS 0.412612f
C348 outp.t1 VSS 0.0109752f
C349 outp.t0 VSS 0.0109752f
C350 outp.n3 VSS 0.0959281f
C351 outp.n4 VSS 0.203595f
C352 outp.t2 VSS 0.021282f
C353 outp.n5 VSS 0.133623f
C354 enb.t0 VSS 0.0392476f
C355 inp.t0 VSS 0.306225f
C356 inp.t1 VSS 0.304214f
C357 inp.n0 VSS 0.260188f
C358 inp.t2 VSS 0.304214f
C359 inp.n1 VSS 0.134058f
C360 inp.t3 VSS 0.304214f
C361 inp.n2 VSS 0.134058f
C362 inp.t4 VSS 0.304214f
C363 inp.n3 VSS 0.134058f
C364 inp.t5 VSS 0.304214f
C365 inp.n4 VSS 0.134058f
C366 inp.t6 VSS 0.304214f
C367 inp.n5 VSS 0.130332f
C368 inp.t15 VSS 0.306225f
C369 inp.t14 VSS 0.304214f
C370 inp.n6 VSS 0.260188f
C371 inp.t13 VSS 0.304214f
C372 inp.n7 VSS 0.134058f
C373 inp.t12 VSS 0.304214f
C374 inp.n8 VSS 0.134058f
C375 inp.t11 VSS 0.304214f
C376 inp.n9 VSS 0.134058f
C377 inp.t10 VSS 0.304214f
C378 inp.n10 VSS 0.134058f
C379 inp.t9 VSS 0.304214f
C380 inp.n11 VSS 0.134058f
C381 inp.t8 VSS 0.304214f
C382 inp.n12 VSS 0.130404f
C383 inp.t7 VSS 0.304214f
C384 inp.n13 VSS 0.112214f
C385 inp.n14 VSS 0.277545f
C386 inn.t0 VSS 0.310527f
C387 inn.t1 VSS 0.309872f
C388 inn.n0 VSS 0.269175f
C389 inn.t2 VSS 0.309872f
C390 inn.n1 VSS 0.145339f
C391 inn.t3 VSS 0.309872f
C392 inn.n2 VSS 0.145339f
C393 inn.t4 VSS 0.309872f
C394 inn.n3 VSS 0.145339f
C395 inn.t5 VSS 0.309872f
C396 inn.n4 VSS 0.145339f
C397 inn.t6 VSS 0.309872f
C398 inn.n5 VSS 0.143929f
C399 inn.t15 VSS 0.310527f
C400 inn.t14 VSS 0.309872f
C401 inn.n6 VSS 0.269175f
C402 inn.t13 VSS 0.309872f
C403 inn.n7 VSS 0.145339f
C404 inn.t12 VSS 0.309872f
C405 inn.n8 VSS 0.145339f
C406 inn.t11 VSS 0.309872f
C407 inn.n9 VSS 0.145339f
C408 inn.t10 VSS 0.309872f
C409 inn.n10 VSS 0.145339f
C410 inn.t9 VSS 0.309872f
C411 inn.n11 VSS 0.145339f
C412 inn.t8 VSS 0.309872f
C413 inn.n12 VSS 0.13421f
C414 inn.t7 VSS 0.309872f
C415 inn.n13 VSS 0.128201f
C416 inn.n14 VSS 0.271925f
C417 nb.t0 VSS 0.190957f
C418 nb.t4 VSS 3.3269f
C419 nb.n0 VSS 0.96541f
C420 nb.t1 VSS 0.187124f
C421 nb.n1 VSS 0.666725f
C422 nb.t3 VSS 0.284988f
C423 nb.t2 VSS 0.282886f
C424 nb.n2 VSS 1.15149f
C425 nb.n3 VSS 1.2348f
.ends
