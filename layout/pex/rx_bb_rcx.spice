* rx_bb: magic R+C extraction of layout/rx_bb.gds (layout/gen/pex.sh)
* rcfix.py: split-net C to VSS scaled by (S - K) / S on 7 nets (coupling double count removed)
* extracted 2026-11-15T23:54:32+01:00 with magic 8.3.642, mode rc, from rx_bb.gds
.subckt rx_bb VDD VSS inp inn outp outn nb enb
X0 t1 inp.t11 o1n VSS.t51 nfet_03v3 ad=10p pd=21u as=10p ps=21u w=20u l=1u
X1 t2 nb.t2 VSS.t66 VSS.t65 nfet_03v3 ad=0.3304p pd=2.76u as=0.1774p ps=1.74u w=0.3u l=0.5u
X2 VSS.t38 o2p VSS.t38 VSS.t30 nfet_03v3 ad=24.57p pd=51.14u as=0 ps=0 w=24.57u l=10u
X3 g2n vgr vb vb pfet_03v3 ad=0.42p pd=2.84u as=0.42p ps=2.84u w=0.42u l=12u
X4 o2p g3p o2p o2p pfet_03v3 ad=12.285p pd=26.57u as=36.855p ps=79.71u w=12.285u l=10u
X5 o1n inp.t14 t1 VSS.t48 nfet_03v3 ad=10p pd=21u as=10p ps=21u w=20u l=1u
X6 t1 inp.t1 o1n VSS.t61 nfet_03v3 ad=10p pd=21u as=10p ps=21u w=20u l=1u
X7 o1n g2n o1n o1n pfet_03v3 ad=12.285p pd=26.57u as=36.855p ps=79.71u w=12.285u l=10u
X8 t1 inp.t5 o1n VSS.t57 nfet_03v3 ad=10p pd=21u as=10p ps=21u w=20u l=1u
X9 VSS.t80 outp.t3 VSS.t80 VSS.t79 nfet_03v3 ad=12.285p pd=25.57u as=0 ps=0 w=24.57u l=10u
X10 VSS.t41 o2p VSS.t41 VSS.t36 nfet_03v3 ad=12.285p pd=25.57u as=0 ps=0 w=24.57u l=10u
X11 g2p vgr vb vb pfet_03v3 ad=0.42p pd=2.84u as=0.42p ps=2.84u w=0.42u l=12u
X12 g3n vgr vb vb pfet_03v3 ad=0.42p pd=2.84u as=0.42p ps=2.84u w=0.42u l=12u
X13 o1n inp.t8 t1 VSS.t54 nfet_03v3 ad=10p pd=21u as=10p ps=21u w=20u l=1u
X14 t1 inn.t10 o1p VSS.t5 nfet_03v3 ad=10p pd=21u as=10p ps=21u w=20u l=1u
X15 t2 g2p o2n VSS.t18 nfet_03v3 ad=2p pd=5u as=4p ps=10u w=4u l=1u
X16 VSS.t40 o2p VSS.t40 VSS.t34 nfet_03v3 ad=12.285p pd=25.57u as=0 ps=0 w=24.57u l=10u
X17 VDD.t6 outp.t2 VSS.t45 ppolyf_u_1k r_width=1u r_length=0.2m
X18 t1 inn.t0 o1p VSS.t15 nfet_03v3 ad=10p pd=21u as=10p ps=21u w=20u l=1u
X19 outp.t0 g3n t3 VSS.t24 nfet_03v3 ad=2p pd=5u as=2p ps=5u w=4u l=1u
X20 VDD.t3 o1n VSS.t27 ppolyf_u r_width=2u r_length=57.14u
X21 o1p inn.t13 t1 VSS.t2 nfet_03v3 ad=10p pd=21u as=10p ps=21u w=20u l=1u
X22 t1 inn.t4 o1p VSS.t11 nfet_03v3 ad=10p pd=21u as=10p ps=21u w=20u l=1u
X23 o1p inn.t3 t1 VSS.t12 nfet_03v3 ad=10p pd=21u as=10p ps=21u w=20u l=1u
X24 VSS.t37 o2n VSS.t37 VSS.t36 nfet_03v3 ad=12.285p pd=25.57u as=0 ps=0 w=24.57u l=10u
X25 mRp2a mRp2a vb vb pfet_03v3 ad=0.42p pd=2.84u as=0.42p ps=2.84u w=0.42u l=1u
X26 mRp2a mRp2a g2p g2p pfet_03v3 ad=0.42p pd=2.84u as=0.42p ps=2.84u w=0.42u l=1u
X27 VSS.t39 o2p VSS.t39 VSS.t32 nfet_03v3 ad=12.285p pd=25.57u as=0 ps=0 w=24.57u l=10u
X28 o1p g2p o1p o1p pfet_03v3 ad=6.1425p pd=13.285u as=36.855p ps=79.71u w=12.285u l=10u
X29 o1p inn.t7 t1 VSS.t8 nfet_03v3 ad=10p pd=21u as=10p ps=21u w=20u l=1u
X30 t1 inp.t15 o1n VSS.t47 nfet_03v3 ad=10p pd=21u as=20p ps=42u w=20u l=1u
X31 t1 inp.t9 o1n VSS.t53 nfet_03v3 ad=10p pd=21u as=10p ps=21u w=20u l=1u
X32 t1 nb.t4 VSS.t68 VSS.t67 nfet_03v3 ad=4p pd=9u as=3.6p ps=16.9u w=8u l=0.5u
X33 VSS.t81 outn.t6 VSS.t81 VSS.t73 nfet_03v3 ad=24.57p pd=51.14u as=0 ps=0 w=24.57u l=10u
X34 mRp3a mRp3a vb vb pfet_03v3 ad=0.42p pd=2.84u as=0.42p ps=2.84u w=0.42u l=1u
X35 outn.t1 g3p t3 VSS.t17 nfet_03v3 ad=4p pd=10u as=2p ps=5u w=4u l=1u
X36 o1n inp.t12 t1 VSS.t50 nfet_03v3 ad=10p pd=21u as=10p ps=21u w=20u l=1u
X37 o1n inp.t2 t1 VSS.t60 nfet_03v3 ad=10p pd=21u as=10p ps=21u w=20u l=1u
X38 vb VSS.t21 VSS.t20 ppolyf_u_1k r_width=1u r_length=99.99u
X39 t1 inn.t14 o1p VSS.t1 nfet_03v3 ad=10p pd=21u as=10p ps=21u w=20u l=1u
X40 t2 g2n o2p VSS.t29 nfet_03v3 ad=2p pd=5u as=2p ps=5u w=4u l=1u
X41 VSS.t78 outp.t4 VSS.t78 VSS.t77 nfet_03v3 ad=12.285p pd=25.57u as=0 ps=0 w=24.57u l=10u
X42 o1n inp.t6 t1 VSS.t56 nfet_03v3 ad=10p pd=21u as=10p ps=21u w=20u l=1u
X43 t1 inn.t8 o1p VSS.t7 nfet_03v3 ad=10p pd=21u as=10p ps=21u w=20u l=1u
X44 VSS.t82 outn.t5 VSS.t82 VSS.t75 nfet_03v3 ad=12.285p pd=25.57u as=0 ps=0 w=24.57u l=10u
X45 VSS.t84 outn.t3 VSS.t84 VSS.t79 nfet_03v3 ad=12.285p pd=25.57u as=0 ps=0 w=24.57u l=10u
X46 VSS.t76 outp.t5 VSS.t76 VSS.t75 nfet_03v3 ad=12.285p pd=25.57u as=0 ps=0 w=24.57u l=10u
X47 vgr vgr vb vb pfet_03v3 ad=4p pd=10u as=4p ps=10u w=4u l=1u
X48 o1p g2p o1p o1p pfet_03v3 ad=12.285p pd=26.57u as=0 ps=0 w=12.285u l=10u
X49 o1p inn.t11 t1 VSS.t4 nfet_03v3 ad=10p pd=21u as=10p ps=21u w=20u l=1u
X50 o1p inn.t1 t1 VSS.t14 nfet_03v3 ad=10p pd=21u as=10p ps=21u w=20u l=1u
X51 VDD.t4 o2p VSS.t42 ppolyf_u_1k r_width=1u r_length=0.2m
X52 o2n g3n o2n o2n pfet_03v3 ad=6.1425p pd=13.285u as=36.855p ps=79.71u w=12.285u l=10u
X53 t1 inp.t13 o1n VSS.t49 nfet_03v3 ad=10p pd=21u as=10p ps=21u w=20u l=1u
X54 t3 nb.t1 VSS.t72 VSS.t71 nfet_03v3 ad=0.8p pd=3.6u as=0.36p ps=2.5u w=0.8u l=0.5u
X55 VSS.t33 o2n VSS.t33 VSS.t32 nfet_03v3 ad=12.285p pd=25.57u as=0 ps=0 w=24.57u l=10u
X56 VSS.t23 vb VSS.t23 VSS.t22 nfet_03v3 ad=24.57p pd=51.14u as=0 ps=0 w=24.57u l=10u
X57 mRp2b mRp2b vb vb pfet_03v3 ad=0.42p pd=2.84u as=0.42p ps=2.84u w=0.42u l=1u
X58 o1p inn.t5 t1 VSS.t10 nfet_03v3 ad=10p pd=21u as=10p ps=21u w=20u l=1u
X59 t1 inp.t3 o1n VSS.t59 nfet_03v3 ad=10p pd=21u as=10p ps=21u w=20u l=1u
X60 VSS.t31 o2n VSS.t31 VSS.t30 nfet_03v3 ad=24.57p pd=51.14u as=0 ps=0 w=24.57u l=10u
X61 vgr nb.t0 VSS.t64 VSS.t63 nfet_03v3 ad=0.42p pd=2.84u as=0.42p ps=2.84u w=0.42u l=50u
X62 VSS.t74 outp.t6 VSS.t74 VSS.t73 nfet_03v3 ad=24.57p pd=51.14u as=0 ps=0 w=24.57u l=10u
X63 vb vbt VSS.t43 ppolyf_u_1k r_width=1u r_length=0.15002m
X64 VDD.t7 o1p VSS.t46 ppolyf_u r_width=2u r_length=57.14u
X65 t1 inp.t7 o1n VSS.t55 nfet_03v3 ad=10p pd=21u as=10p ps=21u w=20u l=1u
X66 mRp3a mRp3a g3p g3p pfet_03v3 ad=0.42p pd=2.84u as=0.42p ps=2.84u w=0.42u l=1u
X67 mRp3b mRp3b g3n g3n pfet_03v3 ad=0.42p pd=2.84u as=0.42p ps=2.84u w=0.42u l=1u
X68 vbt enb.t0 VDD.t1 VDD.t0 pfet_03v3 ad=1p pd=4u as=0.45p ps=2.9u w=1u l=0.28u
X69 t3 g3p outn.t0 VSS.t16 nfet_03v3 ad=2p pd=5u as=4p ps=10u w=4u l=1u
X70 VDD.t2 o2n VSS.t26 ppolyf_u_1k r_width=1u r_length=0.2m
X71 o1n inp.t10 t1 VSS.t52 nfet_03v3 ad=10p pd=21u as=10p ps=21u w=20u l=1u
X72 o1n inp.t0 t1 VSS.t62 nfet_03v3 ad=20p pd=42u as=10p ps=21u w=20u l=1u
X73 t1 inn.t12 o1p VSS.t3 nfet_03v3 ad=10p pd=21u as=10p ps=21u w=20u l=1u
X74 mRp2b mRp2b g2n g2n pfet_03v3 ad=0.42p pd=2.84u as=0.42p ps=2.84u w=0.42u l=1u
X75 t1 inn.t2 o1p VSS.t13 nfet_03v3 ad=10p pd=21u as=10p ps=21u w=20u l=1u
X76 VDD.t5 outn.t2 VSS.t44 ppolyf_u_1k r_width=1u r_length=0.2m
X77 g3p vgr vb vb pfet_03v3 ad=0.42p pd=2.84u as=0.42p ps=2.84u w=0.42u l=12u
X78 o2n g3n o2n o2n pfet_03v3 ad=12.285p pd=26.57u as=0 ps=0 w=12.285u l=10u
X79 o1p inn.t15 t1 VSS.t0 nfet_03v3 ad=10p pd=21u as=10p ps=21u w=20u l=1u
X80 o2p g2n t2 VSS.t28 nfet_03v3 ad=2p pd=5u as=2p ps=5u w=4u l=1u
X81 o2p g3p o2p o2p pfet_03v3 ad=6.1425p pd=13.285u as=0 ps=0 w=12.285u l=10u
X82 VSS.t83 outn.t4 VSS.t83 VSS.t77 nfet_03v3 ad=12.285p pd=25.57u as=0 ps=0 w=24.57u l=10u
X83 o1n g2n o1n o1n pfet_03v3 ad=6.1425p pd=13.285u as=0 ps=0 w=12.285u l=10u
X84 t3 g3n outp.t1 VSS.t25 nfet_03v3 ad=2p pd=5u as=2p ps=5u w=4u l=1u
X85 o1n inp.t4 t1 VSS.t58 nfet_03v3 ad=10p pd=21u as=10p ps=21u w=20u l=1u
X86 t1 inn.t6 o1p VSS.t9 nfet_03v3 ad=10p pd=21u as=10p ps=21u w=20u l=1u
X87 VSS.t70 nb.t3 t1 VSS.t69 nfet_03v3 ad=3.6p pd=16.9u as=4p ps=9u w=8u l=0.5u
X88 VSS.t35 o2n VSS.t35 VSS.t34 nfet_03v3 ad=12.285p pd=25.57u as=0 ps=0 w=24.57u l=10u
X89 mRp3b mRp3b vb vb pfet_03v3 ad=0.42p pd=2.84u as=0.42p ps=2.84u w=0.42u l=1u
X90 o2n g2p t2 VSS.t19 nfet_03v3 ad=4p pd=10u as=2p ps=5u w=4u l=1u
X91 o1p inn.t9 t1 VSS.t6 nfet_03v3 ad=10p pd=21u as=10p ps=21u w=20u l=1u
R0 nb.n0 nb.t4 78.0488
R1 nb.n0 nb.t3 77.6936
R2 nb.n2 nb.t1 31.2559
R3 nb.n1 nb.t2 26.7239
R4 nb nb.t0 21.6743
R5 nb.n3 nb.n2 16.9016
R6 nb nb.n3 7.61971
R7 nb.n3 nb 7.37339
R8 nb nb.n0 3.27958
R9 nb.n2 nb.n1 1.91892
R10 nb.n1 nb 0.141421
R11 inn.n6 inn.t15 90.0019
R12 inn.n0 inn.t0 90.0019
R13 inn.n6 inn.t14 89.5282
R14 inn.n7 inn.t13 89.5282
R15 inn.n8 inn.t12 89.5282
R16 inn.n9 inn.t11 89.5282
R17 inn.n10 inn.t10 89.5282
R18 inn.n11 inn.t9 89.5282
R19 inn.n12 inn.t8 89.5282
R20 inn.n13 inn.t7 89.5282
R21 inn.n5 inn.t6 89.5282
R22 inn.n4 inn.t5 89.5282
R23 inn.n3 inn.t4 89.5282
R24 inn.n2 inn.t3 89.5282
R25 inn.n1 inn.t2 89.5282
R26 inn.n0 inn.t1 89.5282
R27 inn inn.n14 25.0039
R28 inn.n1 inn.n0 1.42155
R29 inn.n3 inn.n2 1.42155
R30 inn.n5 inn.n4 1.42155
R31 inn.n11 inn.n10 1.42155
R32 inn.n9 inn.n8 1.42155
R33 inn.n7 inn.n6 1.42155
R34 inn.n13 inn 0.711026
R35 inn inn.n12 0.711026
R36 inn.n2 inn.n1 0.474184
R37 inn.n4 inn.n3 0.474184
R38 inn.n12 inn.n11 0.474184
R39 inn.n10 inn.n9 0.474184
R40 inn.n8 inn.n7 0.474184
R41 inn.n14 inn.n5 0.384184
R42 inn.n14 inn.n13 0.0905
R43 inp.n6 inp.t15 90.6272
R44 inp.n0 inp.t0 90.6272
R45 inp.n6 inp.t14 89.2061
R46 inp.n7 inp.t13 89.2061
R47 inp.n8 inp.t12 89.2061
R48 inp.n9 inp.t11 89.2061
R49 inp.n10 inp.t10 89.2061
R50 inp.n11 inp.t9 89.2061
R51 inp.n12 inp.t8 89.2061
R52 inp.n13 inp.t7 89.2061
R53 inp.n5 inp.t6 89.2061
R54 inp.n4 inp.t5 89.2061
R55 inp.n3 inp.t4 89.2061
R56 inp.n2 inp.t3 89.2061
R57 inp.n1 inp.t2 89.2061
R58 inp.n0 inp.t1 89.2061
R59 inp inp.n14 24.6818
R60 inp.n2 inp.n1 1.42155
R61 inp.n4 inp.n3 1.42155
R62 inp.n12 inp.n11 1.42155
R63 inp.n10 inp.n9 1.42155
R64 inp.n8 inp.n7 1.42155
R65 inp.n14 inp.n5 1.17997
R66 inp.n1 inp.n0 0.474184
R67 inp.n3 inp.n2 0.474184
R68 inp.n5 inp.n4 0.474184
R69 inp.n11 inp.n10 0.474184
R70 inp.n9 inp.n8 0.474184
R71 inp.n7 inp.n6 0.474184
R72 inp.n14 inp.n13 0.242079
R73 inp.n13 inp 0.237342
R74 inp inp.n12 0.237342
R75 enb enb.t0 38.126
R76 outp.n0 outp.t6 25.5793
R77 outp.n2 outp.t3 23.5756
R78 outp.n0 outp.t5 22.9741
R79 outp.n1 outp.t4 22.9741
R80 outp.n4 outp.n2 17.2237
R81 outp outp.t2 16.1644
R82 outp outp.n3 11.6709
R83 outp.n5 outp 8.07682
R84 outp outp.n5 6.78721
R85 outp.n5 outp.n4 6.76471
R86 outp.n4 outp 5.73563
R87 outp.n2 outp.n1 2.00418
R88 outp.n1 outp 1.30313
R89 outp outp.n0 1.30313
R90 outp.n3 outp.t1 0.788
R91 outp.n3 outp.t0 0.788
R92 outn.n0 outn.t6 24.5621
R93 outn.n2 outn.t3 24.491
R94 outn.n0 outn.t5 21.9568
R95 outn.n1 outn.t4 21.9568
R96 outn.n4 outn.n2 16.7405
R97 outn outn.t2 14.2412
R98 outn.n3 outn.t1 12.7959
R99 outn.n3 outn.t0 10.9012
R100 outn.n5 outn.n4 7.89208
R101 outn.n4 outn 7.17563
R102 outn.n5 outn 6.95892
R103 outn outn.n5 5.98195
R104 outn.n1 outn 1.30313
R105 outn outn.n0 1.30313
R106 outn outn.n3 0.780895
R107 outn.n2 outn.n1 0.0715526
R108 VDD.n33 VDD.t0 54673.9
R109 VDD.n103 VDD.t6 16.2733
R110 VDD.n106 VDD.n105 12.4252
R111 VDD.n105 VDD.t2 12.1049
R112 VDD.n104 VDD.t4 12.1049
R113 VDD.n103 VDD.t5 12.1049
R114 VDD.n108 VDD.n107 11.4921
R115 VDD.n107 VDD.t3 8.73247
R116 VDD.n106 VDD.t7 8.73247
R117 VDD.n121 VDD.t1 7.57826
R118 VDD.n104 VDD.n103 4.16892
R119 VDD.n105 VDD.n104 4.16892
R120 VDD.n107 VDD.n106 2.91366
R121 VDD.n115 VDD.n3 1.5755
R122 VDD.n117 VDD.n116 1.5755
R123 VDD.n79 VDD.n12 1.5755
R124 VDD.n96 VDD.n95 1.5755
R125 VDD.n62 VDD.n61 1.5755
R126 VDD.n72 VDD.n71 1.5755
R127 VDD.n46 VDD.n29 1.5755
R128 VDD.n55 VDD.n54 1.5755
R129 VDD.n38 VDD.n32 1.5755
R130 VDD.n39 VDD.n38 1.5755
R131 VDD VDD.n121 1.54681
R132 VDD.n38 VDD.n37 1.5005
R133 VDD.n46 VDD.n45 1.5005
R134 VDD.n48 VDD.n47 1.5005
R135 VDD.n26 VDD.n25 1.5005
R136 VDD.n54 VDD.n53 1.5005
R137 VDD.n63 VDD.n62 1.5005
R138 VDD.n19 VDD.n18 1.5005
R139 VDD.n70 VDD.n69 1.5005
R140 VDD.n71 VDD.n17 1.5005
R141 VDD.n13 VDD.n12 1.5005
R142 VDD.n85 VDD.n84 1.5005
R143 VDD.n87 VDD.n86 1.5005
R144 VDD.n9 VDD.n8 1.5005
R145 VDD.n94 VDD.n93 1.5005
R146 VDD.n95 VDD.n7 1.5005
R147 VDD.n115 VDD.n114 1.5005
R148 VDD.n116 VDD.n2 1.5005
R149 VDD.n36 VDD.n35 1.5005
R150 VDD.n34 VDD.n31 1.5005
R151 VDD.n40 VDD.n30 1.5005
R152 VDD.n42 VDD.n41 1.5005
R153 VDD.n44 VDD.n43 1.5005
R154 VDD.n28 VDD.n27 1.5005
R155 VDD.n50 VDD.n49 1.5005
R156 VDD.n52 VDD.n51 1.5005
R157 VDD.n24 VDD.n23 1.5005
R158 VDD.n57 VDD.n56 1.5005
R159 VDD.n58 VDD.n22 1.5005
R160 VDD.n60 VDD.n59 1.5005
R161 VDD.n21 VDD.n20 1.5005
R162 VDD.n65 VDD.n64 1.5005
R163 VDD.n67 VDD.n66 1.5005
R164 VDD.n68 VDD.n16 1.5005
R165 VDD.n74 VDD.n73 1.5005
R166 VDD.n75 VDD.n15 1.5005
R167 VDD.n77 VDD.n76 1.5005
R168 VDD.n78 VDD.n14 1.5005
R169 VDD.n81 VDD.n80 1.5005
R170 VDD.n83 VDD.n82 1.5005
R171 VDD.n11 VDD.n10 1.5005
R172 VDD.n89 VDD.n88 1.5005
R173 VDD.n91 VDD.n90 1.5005
R174 VDD.n92 VDD.n6 1.5005
R175 VDD.n98 VDD.n97 1.5005
R176 VDD.n99 VDD.n5 1.5005
R177 VDD.n101 VDD.n100 1.5005
R178 VDD.n102 VDD.n4 1.5005
R179 VDD.n110 VDD.n109 1.5005
R180 VDD.n112 VDD.n111 1.5005
R181 VDD.n113 VDD.n1 1.5005
R182 VDD.n119 VDD.n118 1.5005
R183 VDD.n120 VDD.n0 1.5005
R184 VDD.n33 VDD.n32 0.438696
R185 VDD.n35 VDD.n33 0.0896889
R186 VDD.n116 VDD.n115 0.0755
R187 VDD.n85 VDD.n12 0.0755
R188 VDD.n86 VDD.n85 0.0755
R189 VDD.n86 VDD.n8 0.0755
R190 VDD.n94 VDD.n8 0.0755
R191 VDD.n95 VDD.n94 0.0755
R192 VDD.n62 VDD.n18 0.0755
R193 VDD.n70 VDD.n18 0.0755
R194 VDD.n71 VDD.n70 0.0755
R195 VDD.n47 VDD.n46 0.0755
R196 VDD.n47 VDD.n25 0.0755
R197 VDD.n54 VDD.n25 0.0755
R198 VDD.n35 VDD.n34 0.0755
R199 VDD.n34 VDD.n30 0.0755
R200 VDD.n42 VDD.n30 0.0755
R201 VDD.n43 VDD.n42 0.0755
R202 VDD.n43 VDD.n27 0.0755
R203 VDD.n50 VDD.n27 0.0755
R204 VDD.n51 VDD.n50 0.0755
R205 VDD.n51 VDD.n23 0.0755
R206 VDD.n57 VDD.n23 0.0755
R207 VDD.n58 VDD.n57 0.0755
R208 VDD.n59 VDD.n58 0.0755
R209 VDD.n59 VDD.n20 0.0755
R210 VDD.n65 VDD.n20 0.0755
R211 VDD.n66 VDD.n65 0.0755
R212 VDD.n66 VDD.n16 0.0755
R213 VDD.n74 VDD.n16 0.0755
R214 VDD.n75 VDD.n74 0.0755
R215 VDD.n76 VDD.n75 0.0755
R216 VDD.n76 VDD.n14 0.0755
R217 VDD.n81 VDD.n14 0.0755
R218 VDD.n82 VDD.n81 0.0755
R219 VDD.n82 VDD.n10 0.0755
R220 VDD.n89 VDD.n10 0.0755
R221 VDD.n90 VDD.n89 0.0755
R222 VDD.n90 VDD.n6 0.0755
R223 VDD.n98 VDD.n6 0.0755
R224 VDD.n99 VDD.n98 0.0755
R225 VDD.n100 VDD.n99 0.0755
R226 VDD.n100 VDD.n4 0.0755
R227 VDD.n110 VDD.n4 0.0755
R228 VDD.n111 VDD.n110 0.0755
R229 VDD.n111 VDD.n1 0.0755
R230 VDD.n119 VDD.n1 0.0755
R231 VDD.n120 VDD.n119 0.0755
R232 VDD.n41 VDD.n40 0.0755
R233 VDD.n56 VDD.n22 0.0755
R234 VDD.n60 VDD.n22 0.0755
R235 VDD.n77 VDD.n15 0.0755
R236 VDD.n78 VDD.n77 0.0755
R237 VDD.n101 VDD.n5 0.0755
R238 VDD.n102 VDD.n101 0.0755
R239 VDD.n61 VDD.n60 0.0695
R240 VDD.n63 VDD.n21 0.0695
R241 VDD.n64 VDD.n19 0.0695
R242 VDD.n69 VDD.n67 0.0695
R243 VDD.n68 VDD.n17 0.0695
R244 VDD.n73 VDD.n72 0.0695
R245 VDD.n79 VDD.n78 0.059
R246 VDD.n80 VDD.n13 0.059
R247 VDD.n84 VDD.n83 0.059
R248 VDD.n87 VDD.n11 0.059
R249 VDD.n88 VDD.n9 0.059
R250 VDD.n93 VDD.n91 0.059
R251 VDD.n92 VDD.n7 0.059
R252 VDD.n97 VDD.n96 0.059
R253 VDD.n108 VDD.n102 0.0575
R254 VDD VDD.n0 0.054875
R255 VDD.n121 VDD.n120 0.0498125
R256 VDD.n37 VDD.n36 0.047
R257 VDD.n39 VDD.n31 0.047
R258 VDD.n109 VDD.n3 0.0455
R259 VDD.n114 VDD.n112 0.0455
R260 VDD.n113 VDD.n2 0.0455
R261 VDD.n118 VDD.n117 0.0455
R262 VDD.n44 VDD.n29 0.044
R263 VDD.n45 VDD.n28 0.044
R264 VDD.n49 VDD.n48 0.044
R265 VDD.n52 VDD.n26 0.044
R266 VDD.n53 VDD.n24 0.044
R267 VDD.n56 VDD.n55 0.044
R268 VDD.n41 VDD.n29 0.032
R269 VDD.n45 VDD.n44 0.032
R270 VDD.n48 VDD.n28 0.032
R271 VDD.n49 VDD.n26 0.032
R272 VDD.n53 VDD.n52 0.032
R273 VDD.n55 VDD.n24 0.032
R274 VDD.n112 VDD.n3 0.0305
R275 VDD.n114 VDD.n113 0.0305
R276 VDD.n118 VDD.n2 0.0305
R277 VDD.n117 VDD.n0 0.0305
R278 VDD.n36 VDD.n32 0.029
R279 VDD.n37 VDD.n31 0.029
R280 VDD.n40 VDD.n39 0.029
R281 VDD.n109 VDD.n108 0.0185
R282 VDD.n80 VDD.n79 0.017
R283 VDD.n83 VDD.n13 0.017
R284 VDD.n84 VDD.n11 0.017
R285 VDD.n88 VDD.n87 0.017
R286 VDD.n91 VDD.n9 0.017
R287 VDD.n93 VDD.n92 0.017
R288 VDD.n97 VDD.n7 0.017
R289 VDD.n96 VDD.n5 0.017
R290 VDD.n61 VDD.n21 0.0065
R291 VDD.n64 VDD.n63 0.0065
R292 VDD.n67 VDD.n19 0.0065
R293 VDD.n69 VDD.n68 0.0065
R294 VDD.n73 VDD.n17 0.0065
R295 VDD.n72 VDD.n15 0.0065
R296 VSS.t47 VSS.n715 190208
R297 VSS.n715 VSS.n714 102435
R298 VSS.n712 VSS.n711 94763.9
R299 VSS.n716 VSS.n48 85099.4
R300 VSS.n710 VSS.n47 57973
R301 VSS.n718 VSS.n47 57765.4
R302 VSS.n718 VSS.n48 57765.4
R303 VSS.n715 VSS.t27 36146.7
R304 VSS.t45 VSS.n710 34054.7
R305 VSS.n709 VSS.n47 26745.6
R306 VSS.n717 VSS.n48 26745.6
R307 VSS.n713 VSS.n712 4878.65
R308 VSS.n714 VSS.n713 4805.62
R309 VSS.n713 VSS.n50 3785.29
R310 VSS.n714 VSS.n49 3785.29
R311 VSS.n712 VSS.n51 3386.84
R312 VSS.n49 VSS.t43 924.426
R313 VSS.n51 VSS.n50 718.043
R314 VSS.n50 VSS.n49 707.293
R315 VSS.n710 VSS.t63 629.52
R316 VSS.t46 VSS.t27 354.721
R317 VSS.t43 VSS.t46 300.976
R318 VSS.t44 VSS.t42 247.231
R319 VSS.t42 VSS.t26 247.231
R320 VSS.n711 VSS.t45 197.905
R321 VSS.t20 VSS.t71 192.358
R322 VSS.t16 VSS.t65 165.337
R323 VSS.t67 VSS.t62 145.78
R324 VSS.t79 VSS.t19 138.669
R325 VSS.t63 VSS.t20 131.558
R326 VSS.t17 VSS.t25 71.1126
R327 VSS.t25 VSS.t24 71.1126
R328 VSS.t24 VSS.t16 71.1126
R329 VSS.t19 VSS.t29 71.1126
R330 VSS.t29 VSS.t28 71.1126
R331 VSS.t28 VSS.t18 71.1126
R332 VSS.t14 VSS.t61 71.1126
R333 VSS.t61 VSS.t60 71.1126
R334 VSS.t60 VSS.t13 71.1126
R335 VSS.t13 VSS.t12 71.1126
R336 VSS.t59 VSS.t58 71.1126
R337 VSS.t58 VSS.t11 71.1126
R338 VSS.t11 VSS.t10 71.1126
R339 VSS.t10 VSS.t57 71.1126
R340 VSS.t57 VSS.t56 71.1126
R341 VSS.t9 VSS.t8 71.1126
R342 VSS.t8 VSS.t55 71.1126
R343 VSS.t55 VSS.t54 71.1126
R344 VSS.t54 VSS.t7 71.1126
R345 VSS.t53 VSS.t52 71.1126
R346 VSS.t52 VSS.t5 71.1126
R347 VSS.t5 VSS.t4 71.1126
R348 VSS.t4 VSS.t51 71.1126
R349 VSS.t50 VSS.t3 71.1126
R350 VSS.t3 VSS.t2 71.1126
R351 VSS.t2 VSS.t49 71.1126
R352 VSS.t49 VSS.t48 71.1126
R353 VSS.t48 VSS.t1 71.1126
R354 VSS.n709 VSS.t22 70.4015
R355 VSS.t26 VSS.n51 64.4953
R356 VSS.t75 VSS.t14 64.0014
R357 VSS.t56 VSS.t36 64.0014
R358 VSS.t51 VSS.t32 64.0014
R359 VSS.t22 VSS.t17 60.8013
R360 VSS.t0 VSS.n716 60.268
R361 VSS.n719 VSS.t77 56.8902
R362 VSS.n719 VSS.t69 56.8902
R363 VSS.n718 VSS.t15 56.7124
R364 VSS.t69 VSS.t67 53.3346
R365 VSS.t12 VSS.t73 42.6678
R366 VSS.t34 VSS.t53 42.6678
R367 VSS.t30 VSS.t0 42.6678
R368 VSS.t7 VSS.n717 42.3122
R369 VSS.n711 VSS.t44 40.6985
R370 VSS.t18 VSS.t77 39.1121
R371 VSS.n717 VSS.t6 28.8009
R372 VSS.n334 VSS.t21 28.7656
R373 VSS.t73 VSS.t59 28.4453
R374 VSS.t6 VSS.t34 28.4453
R375 VSS.t1 VSS.t30 28.4453
R376 VSS.t26 VSS.n708 17.0304
R377 VSS.t71 VSS.n709 14.5785
R378 VSS.t62 VSS.n718 14.4007
R379 VSS.n397 VSS.t64 13.9923
R380 VSS.n421 VSS.t66 11.9381
R381 VSS.n716 VSS.t47 10.8451
R382 VSS.n396 VSS.t72 8.62422
R383 VSS.t65 VSS.t79 8.53395
R384 VSS.t15 VSS.t75 7.11171
R385 VSS.t36 VSS.t9 7.11171
R386 VSS.t32 VSS.t50 7.11171
R387 VSS.n491 VSS.n490 5.25298
R388 VSS.n817 VSS.n2 5.23044
R389 VSS.n723 VSS.t70 4.51135
R390 VSS.n721 VSS.t68 4.51135
R391 VSS.n490 VSS.n367 4.23463
R392 VSS.n818 VSS.n817 4.1749
R393 VSS.n815 VSS.t31 3.30157
R394 VSS.n30 VSS.t37 3.30157
R395 VSS.n754 VSS.t81 3.30157
R396 VSS.n430 VSS.t84 3.30157
R397 VSS.n319 VSS.t23 3.30157
R398 VSS.n123 VSS.t23 3.30157
R399 VSS.n304 VSS.t80 3.30157
R400 VSS.n243 VSS.t74 3.30157
R401 VSS.t41 VSS.n158 3.30157
R402 VSS.t38 VSS.n1 3.30157
R403 VSS.n196 VSS.n183 3.17336
R404 VSS.n228 VSS.n165 3.17336
R405 VSS.n804 VSS.n8 3.17336
R406 VSS.n772 VSS.n25 3.17336
R407 VSS.n788 VSS.n17 3.17336
R408 VSS.n752 VSS.n751 3.17336
R409 VSS.n405 VSS.n42 3.17336
R410 VSS.n414 VSS.n406 3.17336
R411 VSS.n287 VSS.n132 3.17336
R412 VSS.n156 VSS.n137 3.17336
R413 VSS.n157 VSS.n147 3.17336
R414 VSS.n212 VSS.n174 3.17336
R415 VSS.n366 VSS.n365 1.5755
R416 VSS.n335 VSS.n106 1.5755
R417 VSS.n332 VSS.n331 1.5755
R418 VSS.n308 VSS.n119 1.5755
R419 VSS.n300 VSS.n122 1.5755
R420 VSS.n232 VSS.n160 1.5755
R421 VSS.n225 VSS.n164 1.5755
R422 VSS.n192 VSS.n191 1.5755
R423 VSS.n492 VSS.n90 1.5755
R424 VSS.n564 VSS.n563 1.5755
R425 VSS.n705 VSS.n704 1.5755
R426 VSS.n618 VSS.n616 1.5755
R427 VSS.n572 VSS.n55 1.5755
R428 VSS.n573 VSS.n572 1.5755
R429 VSS.n426 VSS.n398 1.5755
R430 VSS.n418 VSS.n401 1.5755
R431 VSS.n455 VSS.n454 1.5755
R432 VSS.n439 VSS.n438 1.5755
R433 VSS.n488 VSS.n487 1.5755
R434 VSS.n457 VSS.n382 1.5755
R435 VSS.n775 VSS.n24 1.5755
R436 VSS.n810 VSS.n809 1.5755
R437 VSS.n758 VSS.n32 1.5755
R438 VSS.n768 VSS.n767 1.5755
R439 VSS.n734 VSS.n38 1.5755
R440 VSS.n747 VSS.n746 1.5755
R441 VSS.n727 VSS.n726 1.5755
R442 VSS.n727 VSS.n41 1.5755
R443 VSS.n410 VSS.n404 1.5755
R444 VSS.n410 VSS.n409 1.5755
R445 VSS.n490 VSS.n489 1.56023
R446 VSS.n816 VSS.n815 1.54175
R447 VSS.n818 VSS.n1 1.54175
R448 VSS.n411 VSS.n410 1.5005
R449 VSS.n728 VSS.n727 1.5005
R450 VSS.n39 VSS.n38 1.5005
R451 VSS.n741 VSS.n740 1.5005
R452 VSS.n742 VSS.n36 1.5005
R453 VSS.n748 VSS.n747 1.5005
R454 VSS.n758 VSS.n757 1.5005
R455 VSS.n760 VSS.n759 1.5005
R456 VSS.n29 VSS.n28 1.5005
R457 VSS.n767 VSS.n766 1.5005
R458 VSS.n775 VSS.n774 1.5005
R459 VSS.n777 VSS.n776 1.5005
R460 VSS.n21 VSS.n20 1.5005
R461 VSS.n783 VSS.n782 1.5005
R462 VSS.n785 VSS.n784 1.5005
R463 VSS.n16 VSS.n15 1.5005
R464 VSS.n792 VSS.n791 1.5005
R465 VSS.n794 VSS.n793 1.5005
R466 VSS.n12 VSS.n11 1.5005
R467 VSS.n800 VSS.n799 1.5005
R468 VSS.n802 VSS.n801 1.5005
R469 VSS.n7 VSS.n6 1.5005
R470 VSS.n809 VSS.n808 1.5005
R471 VSS.n487 VSS.n486 1.5005
R472 VSS.n371 VSS.n370 1.5005
R473 VSS.n481 VSS.n480 1.5005
R474 VSS.n479 VSS.n478 1.5005
R475 VSS.n375 VSS.n374 1.5005
R476 VSS.n473 VSS.n472 1.5005
R477 VSS.n471 VSS.n470 1.5005
R478 VSS.n379 VSS.n378 1.5005
R479 VSS.n465 VSS.n464 1.5005
R480 VSS.n463 VSS.n462 1.5005
R481 VSS.n383 VSS.n382 1.5005
R482 VSS.n454 VSS.n453 1.5005
R483 VSS.n387 VSS.n386 1.5005
R484 VSS.n448 VSS.n447 1.5005
R485 VSS.n446 VSS.n445 1.5005
R486 VSS.n392 VSS.n391 1.5005
R487 VSS.n440 VSS.n439 1.5005
R488 VSS.n427 VSS.n426 1.5005
R489 VSS.n425 VSS.n424 1.5005
R490 VSS.n402 VSS.n401 1.5005
R491 VSS.n369 VSS.n368 1.5005
R492 VSS.n485 VSS.n484 1.5005
R493 VSS.n483 VSS.n482 1.5005
R494 VSS.n373 VSS.n372 1.5005
R495 VSS.n477 VSS.n476 1.5005
R496 VSS.n475 VSS.n474 1.5005
R497 VSS.n377 VSS.n376 1.5005
R498 VSS.n469 VSS.n468 1.5005
R499 VSS.n467 VSS.n466 1.5005
R500 VSS.n381 VSS.n380 1.5005
R501 VSS.n461 VSS.n460 1.5005
R502 VSS.n459 VSS.n458 1.5005
R503 VSS.n456 VSS.n384 1.5005
R504 VSS.n388 VSS.n385 1.5005
R505 VSS.n452 VSS.n451 1.5005
R506 VSS.n450 VSS.n449 1.5005
R507 VSS.n390 VSS.n389 1.5005
R508 VSS.n444 VSS.n443 1.5005
R509 VSS.n442 VSS.n441 1.5005
R510 VSS.n394 VSS.n393 1.5005
R511 VSS.n437 VSS.n436 1.5005
R512 VSS.n435 VSS.n395 1.5005
R513 VSS.n434 VSS.n433 1.5005
R514 VSS.n432 VSS.n431 1.5005
R515 VSS.n429 VSS.n428 1.5005
R516 VSS.n400 VSS.n399 1.5005
R517 VSS.n423 VSS.n422 1.5005
R518 VSS.n420 VSS.n419 1.5005
R519 VSS.n417 VSS.n403 1.5005
R520 VSS.n416 VSS.n415 1.5005
R521 VSS.n413 VSS.n412 1.5005
R522 VSS.n408 VSS.n407 1.5005
R523 VSS.n45 VSS.n44 1.5005
R524 VSS.n725 VSS.n724 1.5005
R525 VSS.n722 VSS.n43 1.5005
R526 VSS.n730 VSS.n729 1.5005
R527 VSS.n732 VSS.n731 1.5005
R528 VSS.n733 VSS.n40 1.5005
R529 VSS.n736 VSS.n735 1.5005
R530 VSS.n738 VSS.n737 1.5005
R531 VSS.n739 VSS.n34 1.5005
R532 VSS.n750 VSS.n749 1.5005
R533 VSS.n37 VSS.n35 1.5005
R534 VSS.n745 VSS.n744 1.5005
R535 VSS.n743 VSS.n33 1.5005
R536 VSS.n756 VSS.n755 1.5005
R537 VSS.n753 VSS.n31 1.5005
R538 VSS.n762 VSS.n761 1.5005
R539 VSS.n765 VSS.n764 1.5005
R540 VSS.n763 VSS.n27 1.5005
R541 VSS.n769 VSS.n26 1.5005
R542 VSS.n771 VSS.n770 1.5005
R543 VSS.n773 VSS.n772 1.5005
R544 VSS.n23 VSS.n22 1.5005
R545 VSS.n779 VSS.n778 1.5005
R546 VSS.n781 VSS.n780 1.5005
R547 VSS.n19 VSS.n18 1.5005
R548 VSS.n787 VSS.n786 1.5005
R549 VSS.n790 VSS.n789 1.5005
R550 VSS.n14 VSS.n13 1.5005
R551 VSS.n796 VSS.n795 1.5005
R552 VSS.n798 VSS.n797 1.5005
R553 VSS.n10 VSS.n9 1.5005
R554 VSS.n804 VSS.n803 1.5005
R555 VSS.n807 VSS.n806 1.5005
R556 VSS.n805 VSS.n5 1.5005
R557 VSS.n811 VSS.n4 1.5005
R558 VSS.n813 VSS.n812 1.5005
R559 VSS.n814 VSS.n3 1.5005
R560 VSS.n494 VSS.n493 1.5005
R561 VSS.n496 VSS.n495 1.5005
R562 VSS.n89 VSS.n88 1.5005
R563 VSS.n502 VSS.n501 1.5005
R564 VSS.n504 VSS.n503 1.5005
R565 VSS.n85 VSS.n84 1.5005
R566 VSS.n510 VSS.n509 1.5005
R567 VSS.n512 VSS.n511 1.5005
R568 VSS.n81 VSS.n80 1.5005
R569 VSS.n518 VSS.n517 1.5005
R570 VSS.n520 VSS.n519 1.5005
R571 VSS.n77 VSS.n76 1.5005
R572 VSS.n526 VSS.n525 1.5005
R573 VSS.n528 VSS.n527 1.5005
R574 VSS.n73 VSS.n72 1.5005
R575 VSS.n534 VSS.n533 1.5005
R576 VSS.n536 VSS.n535 1.5005
R577 VSS.n69 VSS.n68 1.5005
R578 VSS.n542 VSS.n541 1.5005
R579 VSS.n544 VSS.n543 1.5005
R580 VSS.n65 VSS.n64 1.5005
R581 VSS.n550 VSS.n549 1.5005
R582 VSS.n552 VSS.n551 1.5005
R583 VSS.n61 VSS.n60 1.5005
R584 VSS.n558 VSS.n557 1.5005
R585 VSS.n561 VSS.n560 1.5005
R586 VSS.n572 VSS.n571 1.5005
R587 VSS.n704 VSS.n703 1.5005
R588 VSS.n577 VSS.n576 1.5005
R589 VSS.n698 VSS.n697 1.5005
R590 VSS.n696 VSS.n695 1.5005
R591 VSS.n581 VSS.n580 1.5005
R592 VSS.n690 VSS.n689 1.5005
R593 VSS.n688 VSS.n687 1.5005
R594 VSS.n585 VSS.n584 1.5005
R595 VSS.n682 VSS.n681 1.5005
R596 VSS.n680 VSS.n679 1.5005
R597 VSS.n589 VSS.n588 1.5005
R598 VSS.n674 VSS.n673 1.5005
R599 VSS.n672 VSS.n671 1.5005
R600 VSS.n593 VSS.n592 1.5005
R601 VSS.n666 VSS.n665 1.5005
R602 VSS.n664 VSS.n663 1.5005
R603 VSS.n597 VSS.n596 1.5005
R604 VSS.n658 VSS.n657 1.5005
R605 VSS.n656 VSS.n655 1.5005
R606 VSS.n601 VSS.n600 1.5005
R607 VSS.n650 VSS.n649 1.5005
R608 VSS.n648 VSS.n647 1.5005
R609 VSS.n605 VSS.n604 1.5005
R610 VSS.n642 VSS.n641 1.5005
R611 VSS.n640 VSS.n639 1.5005
R612 VSS.n609 VSS.n608 1.5005
R613 VSS.n634 VSS.n633 1.5005
R614 VSS.n632 VSS.n631 1.5005
R615 VSS.n613 VSS.n612 1.5005
R616 VSS.n626 VSS.n625 1.5005
R617 VSS.n624 VSS.n623 1.5005
R618 VSS.n617 VSS.n616 1.5005
R619 VSS.n91 VSS.n90 1.5005
R620 VSS.n498 VSS.n497 1.5005
R621 VSS.n500 VSS.n499 1.5005
R622 VSS.n87 VSS.n86 1.5005
R623 VSS.n506 VSS.n505 1.5005
R624 VSS.n508 VSS.n507 1.5005
R625 VSS.n83 VSS.n82 1.5005
R626 VSS.n514 VSS.n513 1.5005
R627 VSS.n516 VSS.n515 1.5005
R628 VSS.n79 VSS.n78 1.5005
R629 VSS.n522 VSS.n521 1.5005
R630 VSS.n524 VSS.n523 1.5005
R631 VSS.n75 VSS.n74 1.5005
R632 VSS.n530 VSS.n529 1.5005
R633 VSS.n532 VSS.n531 1.5005
R634 VSS.n71 VSS.n70 1.5005
R635 VSS.n538 VSS.n537 1.5005
R636 VSS.n540 VSS.n539 1.5005
R637 VSS.n67 VSS.n66 1.5005
R638 VSS.n546 VSS.n545 1.5005
R639 VSS.n548 VSS.n547 1.5005
R640 VSS.n63 VSS.n62 1.5005
R641 VSS.n554 VSS.n553 1.5005
R642 VSS.n556 VSS.n555 1.5005
R643 VSS.n59 VSS.n58 1.5005
R644 VSS.n563 VSS.n562 1.5005
R645 VSS.n559 VSS.n57 1.5005
R646 VSS.n565 VSS.n56 1.5005
R647 VSS.n567 VSS.n566 1.5005
R648 VSS.n570 VSS.n569 1.5005
R649 VSS.n568 VSS.n54 1.5005
R650 VSS.n574 VSS.n52 1.5005
R651 VSS.n707 VSS.n706 1.5005
R652 VSS.n575 VSS.n53 1.5005
R653 VSS.n702 VSS.n701 1.5005
R654 VSS.n700 VSS.n699 1.5005
R655 VSS.n579 VSS.n578 1.5005
R656 VSS.n694 VSS.n693 1.5005
R657 VSS.n692 VSS.n691 1.5005
R658 VSS.n583 VSS.n582 1.5005
R659 VSS.n686 VSS.n685 1.5005
R660 VSS.n684 VSS.n683 1.5005
R661 VSS.n587 VSS.n586 1.5005
R662 VSS.n678 VSS.n677 1.5005
R663 VSS.n676 VSS.n675 1.5005
R664 VSS.n591 VSS.n590 1.5005
R665 VSS.n670 VSS.n669 1.5005
R666 VSS.n668 VSS.n667 1.5005
R667 VSS.n595 VSS.n594 1.5005
R668 VSS.n662 VSS.n661 1.5005
R669 VSS.n660 VSS.n659 1.5005
R670 VSS.n599 VSS.n598 1.5005
R671 VSS.n654 VSS.n653 1.5005
R672 VSS.n652 VSS.n651 1.5005
R673 VSS.n603 VSS.n602 1.5005
R674 VSS.n646 VSS.n645 1.5005
R675 VSS.n644 VSS.n643 1.5005
R676 VSS.n607 VSS.n606 1.5005
R677 VSS.n638 VSS.n637 1.5005
R678 VSS.n636 VSS.n635 1.5005
R679 VSS.n611 VSS.n610 1.5005
R680 VSS.n630 VSS.n629 1.5005
R681 VSS.n628 VSS.n627 1.5005
R682 VSS.n615 VSS.n614 1.5005
R683 VSS.n622 VSS.n621 1.5005
R684 VSS.n620 VSS.n619 1.5005
R685 VSS.n817 VSS.n816 1.5005
R686 VSS.n193 VSS.n192 1.5005
R687 VSS.n182 VSS.n181 1.5005
R688 VSS.n199 VSS.n198 1.5005
R689 VSS.n201 VSS.n200 1.5005
R690 VSS.n178 VSS.n177 1.5005
R691 VSS.n207 VSS.n206 1.5005
R692 VSS.n209 VSS.n208 1.5005
R693 VSS.n173 VSS.n172 1.5005
R694 VSS.n216 VSS.n215 1.5005
R695 VSS.n218 VSS.n217 1.5005
R696 VSS.n169 VSS.n168 1.5005
R697 VSS.n224 VSS.n223 1.5005
R698 VSS.n226 VSS.n225 1.5005
R699 VSS.n161 VSS.n160 1.5005
R700 VSS.n238 VSS.n237 1.5005
R701 VSS.n240 VSS.n239 1.5005
R702 VSS.n155 VSS.n154 1.5005
R703 VSS.n247 VSS.n246 1.5005
R704 VSS.n249 VSS.n248 1.5005
R705 VSS.n150 VSS.n149 1.5005
R706 VSS.n255 VSS.n254 1.5005
R707 VSS.n257 VSS.n256 1.5005
R708 VSS.n146 VSS.n145 1.5005
R709 VSS.n263 VSS.n262 1.5005
R710 VSS.n265 VSS.n264 1.5005
R711 VSS.n141 VSS.n140 1.5005
R712 VSS.n271 VSS.n270 1.5005
R713 VSS.n273 VSS.n272 1.5005
R714 VSS.n139 VSS.n136 1.5005
R715 VSS.n278 VSS.n135 1.5005
R716 VSS.n282 VSS.n281 1.5005
R717 VSS.n284 VSS.n283 1.5005
R718 VSS.n131 VSS.n130 1.5005
R719 VSS.n291 VSS.n290 1.5005
R720 VSS.n293 VSS.n292 1.5005
R721 VSS.n127 VSS.n126 1.5005
R722 VSS.n299 VSS.n298 1.5005
R723 VSS.n301 VSS.n300 1.5005
R724 VSS.n120 VSS.n119 1.5005
R725 VSS.n314 VSS.n313 1.5005
R726 VSS.n316 VSS.n315 1.5005
R727 VSS.n116 VSS.n115 1.5005
R728 VSS.n323 VSS.n322 1.5005
R729 VSS.n325 VSS.n324 1.5005
R730 VSS.n111 VSS.n110 1.5005
R731 VSS.n331 VSS.n330 1.5005
R732 VSS.n107 VSS.n106 1.5005
R733 VSS.n341 VSS.n340 1.5005
R734 VSS.n343 VSS.n342 1.5005
R735 VSS.n103 VSS.n102 1.5005
R736 VSS.n349 VSS.n348 1.5005
R737 VSS.n351 VSS.n350 1.5005
R738 VSS.n99 VSS.n98 1.5005
R739 VSS.n357 VSS.n356 1.5005
R740 VSS.n359 VSS.n358 1.5005
R741 VSS.n95 VSS.n94 1.5005
R742 VSS.n365 VSS.n364 1.5005
R743 VSS.n93 VSS.n92 1.5005
R744 VSS.n363 VSS.n362 1.5005
R745 VSS.n361 VSS.n360 1.5005
R746 VSS.n97 VSS.n96 1.5005
R747 VSS.n355 VSS.n354 1.5005
R748 VSS.n353 VSS.n352 1.5005
R749 VSS.n101 VSS.n100 1.5005
R750 VSS.n347 VSS.n346 1.5005
R751 VSS.n345 VSS.n344 1.5005
R752 VSS.n105 VSS.n104 1.5005
R753 VSS.n339 VSS.n338 1.5005
R754 VSS.n337 VSS.n336 1.5005
R755 VSS.n333 VSS.n108 1.5005
R756 VSS.n112 VSS.n109 1.5005
R757 VSS.n329 VSS.n328 1.5005
R758 VSS.n327 VSS.n326 1.5005
R759 VSS.n114 VSS.n113 1.5005
R760 VSS.n321 VSS.n320 1.5005
R761 VSS.n318 VSS.n317 1.5005
R762 VSS.n118 VSS.n117 1.5005
R763 VSS.n312 VSS.n311 1.5005
R764 VSS.n310 VSS.n309 1.5005
R765 VSS.n307 VSS.n121 1.5005
R766 VSS.n306 VSS.n305 1.5005
R767 VSS.n303 VSS.n302 1.5005
R768 VSS.n125 VSS.n124 1.5005
R769 VSS.n297 VSS.n296 1.5005
R770 VSS.n295 VSS.n294 1.5005
R771 VSS.n129 VSS.n128 1.5005
R772 VSS.n289 VSS.n288 1.5005
R773 VSS.n286 VSS.n285 1.5005
R774 VSS.n134 VSS.n133 1.5005
R775 VSS.n280 VSS.n279 1.5005
R776 VSS.n277 VSS.n276 1.5005
R777 VSS.n275 VSS.n274 1.5005
R778 VSS.n142 VSS.n138 1.5005
R779 VSS.n269 VSS.n268 1.5005
R780 VSS.n267 VSS.n266 1.5005
R781 VSS.n144 VSS.n143 1.5005
R782 VSS.n261 VSS.n260 1.5005
R783 VSS.n259 VSS.n258 1.5005
R784 VSS.n151 VSS.n148 1.5005
R785 VSS.n253 VSS.n252 1.5005
R786 VSS.n251 VSS.n250 1.5005
R787 VSS.n153 VSS.n152 1.5005
R788 VSS.n245 VSS.n244 1.5005
R789 VSS.n242 VSS.n241 1.5005
R790 VSS.n162 VSS.n159 1.5005
R791 VSS.n236 VSS.n235 1.5005
R792 VSS.n234 VSS.n233 1.5005
R793 VSS.n231 VSS.n163 1.5005
R794 VSS.n230 VSS.n229 1.5005
R795 VSS.n228 VSS.n227 1.5005
R796 VSS.n167 VSS.n166 1.5005
R797 VSS.n222 VSS.n221 1.5005
R798 VSS.n220 VSS.n219 1.5005
R799 VSS.n171 VSS.n170 1.5005
R800 VSS.n214 VSS.n213 1.5005
R801 VSS.n211 VSS.n210 1.5005
R802 VSS.n176 VSS.n175 1.5005
R803 VSS.n205 VSS.n204 1.5005
R804 VSS.n203 VSS.n202 1.5005
R805 VSS.n180 VSS.n179 1.5005
R806 VSS.n197 VSS.n196 1.5005
R807 VSS.n195 VSS.n194 1.5005
R808 VSS.n185 VSS.n184 1.5005
R809 VSS.n190 VSS.n189 1.5005
R810 VSS.n188 VSS.n186 1.5005
R811 VSS.n187 VSS.n0 1.5005
R812 VSS.n489 VSS.n368 0.591859
R813 VSS.n367 VSS.n92 0.591859
R814 VSS.n620 VSS.n2 0.585263
R815 VSS.n494 VSS.n491 0.474199
R816 VSS.n183 VSS.t39 0.128705
R817 VSS.n183 VSS.t38 0.128705
R818 VSS.n165 VSS.t41 0.128705
R819 VSS.t40 VSS.n165 0.128705
R820 VSS.t33 VSS.n8 0.128705
R821 VSS.n8 VSS.t31 0.128705
R822 VSS.t37 VSS.n25 0.128705
R823 VSS.n25 VSS.t35 0.128705
R824 VSS.t35 VSS.n17 0.128705
R825 VSS.n17 VSS.t33 0.128705
R826 VSS.n752 VSS.t82 0.128705
R827 VSS.t81 VSS.n752 0.128705
R828 VSS.t83 VSS.n405 0.128705
R829 VSS.n405 VSS.t82 0.128705
R830 VSS.n406 VSS.t84 0.128705
R831 VSS.n406 VSS.t83 0.128705
R832 VSS.n132 VSS.t80 0.128705
R833 VSS.t78 VSS.n132 0.128705
R834 VSS.n156 VSS.t78 0.128705
R835 VSS.t76 VSS.n156 0.128705
R836 VSS.n157 VSS.t76 0.128705
R837 VSS.t74 VSS.n157 0.128705
R838 VSS.n174 VSS.t40 0.128705
R839 VSS.t39 VSS.n174 0.128705
R840 VSS.n618 VSS.n2 0.117112
R841 VSS.n492 VSS.n491 0.101757
R842 VSS.n489 VSS.n488 0.0913918
R843 VSS.n367 VSS.n366 0.0913918
R844 VSS.n365 VSS.n94 0.0755
R845 VSS.n358 VSS.n94 0.0755
R846 VSS.n358 VSS.n357 0.0755
R847 VSS.n357 VSS.n98 0.0755
R848 VSS.n350 VSS.n98 0.0755
R849 VSS.n350 VSS.n349 0.0755
R850 VSS.n349 VSS.n102 0.0755
R851 VSS.n342 VSS.n102 0.0755
R852 VSS.n342 VSS.n341 0.0755
R853 VSS.n341 VSS.n106 0.0755
R854 VSS.n331 VSS.n110 0.0755
R855 VSS.n324 VSS.n110 0.0755
R856 VSS.n324 VSS.n323 0.0755
R857 VSS.n323 VSS.n115 0.0755
R858 VSS.n315 VSS.n115 0.0755
R859 VSS.n315 VSS.n314 0.0755
R860 VSS.n314 VSS.n119 0.0755
R861 VSS.n300 VSS.n299 0.0755
R862 VSS.n299 VSS.n126 0.0755
R863 VSS.n292 VSS.n126 0.0755
R864 VSS.n292 VSS.n291 0.0755
R865 VSS.n291 VSS.n130 0.0755
R866 VSS.n283 VSS.n130 0.0755
R867 VSS.n283 VSS.n282 0.0755
R868 VSS.n282 VSS.n135 0.0755
R869 VSS.n139 VSS.n135 0.0755
R870 VSS.n272 VSS.n139 0.0755
R871 VSS.n272 VSS.n271 0.0755
R872 VSS.n271 VSS.n140 0.0755
R873 VSS.n264 VSS.n140 0.0755
R874 VSS.n264 VSS.n263 0.0755
R875 VSS.n263 VSS.n145 0.0755
R876 VSS.n256 VSS.n145 0.0755
R877 VSS.n256 VSS.n255 0.0755
R878 VSS.n255 VSS.n149 0.0755
R879 VSS.n248 VSS.n149 0.0755
R880 VSS.n248 VSS.n247 0.0755
R881 VSS.n247 VSS.n154 0.0755
R882 VSS.n239 VSS.n154 0.0755
R883 VSS.n239 VSS.n238 0.0755
R884 VSS.n238 VSS.n160 0.0755
R885 VSS.n225 VSS.n224 0.0755
R886 VSS.n224 VSS.n168 0.0755
R887 VSS.n217 VSS.n168 0.0755
R888 VSS.n217 VSS.n216 0.0755
R889 VSS.n216 VSS.n172 0.0755
R890 VSS.n208 VSS.n172 0.0755
R891 VSS.n208 VSS.n207 0.0755
R892 VSS.n207 VSS.n177 0.0755
R893 VSS.n200 VSS.n177 0.0755
R894 VSS.n200 VSS.n199 0.0755
R895 VSS.n199 VSS.n181 0.0755
R896 VSS.n192 VSS.n181 0.0755
R897 VSS.n498 VSS.n90 0.0755
R898 VSS.n499 VSS.n498 0.0755
R899 VSS.n499 VSS.n86 0.0755
R900 VSS.n506 VSS.n86 0.0755
R901 VSS.n507 VSS.n506 0.0755
R902 VSS.n507 VSS.n82 0.0755
R903 VSS.n514 VSS.n82 0.0755
R904 VSS.n515 VSS.n514 0.0755
R905 VSS.n515 VSS.n78 0.0755
R906 VSS.n522 VSS.n78 0.0755
R907 VSS.n523 VSS.n522 0.0755
R908 VSS.n523 VSS.n74 0.0755
R909 VSS.n530 VSS.n74 0.0755
R910 VSS.n531 VSS.n530 0.0755
R911 VSS.n531 VSS.n70 0.0755
R912 VSS.n538 VSS.n70 0.0755
R913 VSS.n539 VSS.n538 0.0755
R914 VSS.n539 VSS.n66 0.0755
R915 VSS.n546 VSS.n66 0.0755
R916 VSS.n547 VSS.n546 0.0755
R917 VSS.n547 VSS.n62 0.0755
R918 VSS.n554 VSS.n62 0.0755
R919 VSS.n555 VSS.n554 0.0755
R920 VSS.n555 VSS.n58 0.0755
R921 VSS.n563 VSS.n58 0.0755
R922 VSS.n704 VSS.n576 0.0755
R923 VSS.n697 VSS.n576 0.0755
R924 VSS.n697 VSS.n696 0.0755
R925 VSS.n696 VSS.n580 0.0755
R926 VSS.n689 VSS.n580 0.0755
R927 VSS.n689 VSS.n688 0.0755
R928 VSS.n688 VSS.n584 0.0755
R929 VSS.n681 VSS.n584 0.0755
R930 VSS.n681 VSS.n680 0.0755
R931 VSS.n680 VSS.n588 0.0755
R932 VSS.n673 VSS.n588 0.0755
R933 VSS.n673 VSS.n672 0.0755
R934 VSS.n672 VSS.n592 0.0755
R935 VSS.n665 VSS.n592 0.0755
R936 VSS.n665 VSS.n664 0.0755
R937 VSS.n664 VSS.n596 0.0755
R938 VSS.n657 VSS.n596 0.0755
R939 VSS.n657 VSS.n656 0.0755
R940 VSS.n656 VSS.n600 0.0755
R941 VSS.n649 VSS.n600 0.0755
R942 VSS.n649 VSS.n648 0.0755
R943 VSS.n648 VSS.n604 0.0755
R944 VSS.n641 VSS.n604 0.0755
R945 VSS.n641 VSS.n640 0.0755
R946 VSS.n640 VSS.n608 0.0755
R947 VSS.n633 VSS.n608 0.0755
R948 VSS.n633 VSS.n632 0.0755
R949 VSS.n632 VSS.n612 0.0755
R950 VSS.n625 VSS.n612 0.0755
R951 VSS.n625 VSS.n624 0.0755
R952 VSS.n624 VSS.n616 0.0755
R953 VSS.n426 VSS.n425 0.0755
R954 VSS.n425 VSS.n401 0.0755
R955 VSS.n454 VSS.n386 0.0755
R956 VSS.n447 VSS.n386 0.0755
R957 VSS.n447 VSS.n446 0.0755
R958 VSS.n446 VSS.n391 0.0755
R959 VSS.n439 VSS.n391 0.0755
R960 VSS.n487 VSS.n370 0.0755
R961 VSS.n480 VSS.n370 0.0755
R962 VSS.n480 VSS.n479 0.0755
R963 VSS.n479 VSS.n374 0.0755
R964 VSS.n472 VSS.n374 0.0755
R965 VSS.n472 VSS.n471 0.0755
R966 VSS.n471 VSS.n378 0.0755
R967 VSS.n464 VSS.n378 0.0755
R968 VSS.n464 VSS.n463 0.0755
R969 VSS.n463 VSS.n382 0.0755
R970 VSS.n776 VSS.n775 0.0755
R971 VSS.n776 VSS.n20 0.0755
R972 VSS.n783 VSS.n20 0.0755
R973 VSS.n784 VSS.n783 0.0755
R974 VSS.n784 VSS.n15 0.0755
R975 VSS.n792 VSS.n15 0.0755
R976 VSS.n793 VSS.n792 0.0755
R977 VSS.n793 VSS.n11 0.0755
R978 VSS.n800 VSS.n11 0.0755
R979 VSS.n801 VSS.n800 0.0755
R980 VSS.n801 VSS.n6 0.0755
R981 VSS.n809 VSS.n6 0.0755
R982 VSS.n759 VSS.n758 0.0755
R983 VSS.n759 VSS.n28 0.0755
R984 VSS.n767 VSS.n28 0.0755
R985 VSS.n741 VSS.n38 0.0755
R986 VSS.n742 VSS.n741 0.0755
R987 VSS.n747 VSS.n742 0.0755
R988 VSS.n437 VSS.n395 0.0755
R989 VSS.n433 VSS.n395 0.0755
R990 VSS.n433 VSS.n432 0.0755
R991 VSS.n417 VSS.n416 0.0755
R992 VSS.n725 VSS.n44 0.0755
R993 VSS.n733 VSS.n732 0.0755
R994 VSS.n745 VSS.n743 0.0755
R995 VSS.n770 VSS.n769 0.0755
R996 VSS.n812 VSS.n811 0.0755
R997 VSS.n812 VSS.n3 0.0755
R998 VSS.n484 VSS.n368 0.0755
R999 VSS.n484 VSS.n483 0.0755
R1000 VSS.n483 VSS.n372 0.0755
R1001 VSS.n476 VSS.n372 0.0755
R1002 VSS.n476 VSS.n475 0.0755
R1003 VSS.n475 VSS.n376 0.0755
R1004 VSS.n468 VSS.n376 0.0755
R1005 VSS.n468 VSS.n467 0.0755
R1006 VSS.n467 VSS.n380 0.0755
R1007 VSS.n460 VSS.n380 0.0755
R1008 VSS.n460 VSS.n459 0.0755
R1009 VSS.n459 VSS.n384 0.0755
R1010 VSS.n388 VSS.n384 0.0755
R1011 VSS.n451 VSS.n388 0.0755
R1012 VSS.n451 VSS.n450 0.0755
R1013 VSS.n450 VSS.n389 0.0755
R1014 VSS.n443 VSS.n389 0.0755
R1015 VSS.n443 VSS.n442 0.0755
R1016 VSS.n442 VSS.n393 0.0755
R1017 VSS.n436 VSS.n435 0.0755
R1018 VSS.n435 VSS.n434 0.0755
R1019 VSS.n429 VSS.n399 0.0755
R1020 VSS.n422 VSS.n399 0.0755
R1021 VSS.n420 VSS.n403 0.0755
R1022 VSS.n415 VSS.n403 0.0755
R1023 VSS.n413 VSS.n407 0.0755
R1024 VSS.n407 VSS.n45 0.0755
R1025 VSS.n731 VSS.n730 0.0755
R1026 VSS.n731 VSS.n40 0.0755
R1027 VSS.n736 VSS.n40 0.0755
R1028 VSS.n737 VSS.n736 0.0755
R1029 VSS.n737 VSS.n34 0.0755
R1030 VSS.n750 VSS.n35 0.0755
R1031 VSS.n744 VSS.n35 0.0755
R1032 VSS.n744 VSS.n33 0.0755
R1033 VSS.n755 VSS.n33 0.0755
R1034 VSS.n764 VSS.n762 0.0755
R1035 VSS.n764 VSS.n763 0.0755
R1036 VSS.n763 VSS.n26 0.0755
R1037 VSS.n771 VSS.n26 0.0755
R1038 VSS.n772 VSS.n771 0.0755
R1039 VSS.n772 VSS.n22 0.0755
R1040 VSS.n779 VSS.n22 0.0755
R1041 VSS.n780 VSS.n779 0.0755
R1042 VSS.n780 VSS.n18 0.0755
R1043 VSS.n787 VSS.n18 0.0755
R1044 VSS.n789 VSS.n13 0.0755
R1045 VSS.n796 VSS.n13 0.0755
R1046 VSS.n797 VSS.n796 0.0755
R1047 VSS.n797 VSS.n9 0.0755
R1048 VSS.n804 VSS.n9 0.0755
R1049 VSS.n806 VSS.n804 0.0755
R1050 VSS.n806 VSS.n805 0.0755
R1051 VSS.n805 VSS.n4 0.0755
R1052 VSS.n813 VSS.n4 0.0755
R1053 VSS.n814 VSS.n813 0.0755
R1054 VSS.n362 VSS.n92 0.0755
R1055 VSS.n362 VSS.n361 0.0755
R1056 VSS.n361 VSS.n96 0.0755
R1057 VSS.n354 VSS.n96 0.0755
R1058 VSS.n354 VSS.n353 0.0755
R1059 VSS.n353 VSS.n100 0.0755
R1060 VSS.n346 VSS.n100 0.0755
R1061 VSS.n346 VSS.n345 0.0755
R1062 VSS.n345 VSS.n104 0.0755
R1063 VSS.n338 VSS.n104 0.0755
R1064 VSS.n338 VSS.n337 0.0755
R1065 VSS.n337 VSS.n108 0.0755
R1066 VSS.n112 VSS.n108 0.0755
R1067 VSS.n328 VSS.n112 0.0755
R1068 VSS.n328 VSS.n327 0.0755
R1069 VSS.n327 VSS.n113 0.0755
R1070 VSS.n320 VSS.n113 0.0755
R1071 VSS.n318 VSS.n117 0.0755
R1072 VSS.n311 VSS.n117 0.0755
R1073 VSS.n311 VSS.n310 0.0755
R1074 VSS.n310 VSS.n121 0.0755
R1075 VSS.n303 VSS.n124 0.0755
R1076 VSS.n296 VSS.n124 0.0755
R1077 VSS.n296 VSS.n295 0.0755
R1078 VSS.n295 VSS.n128 0.0755
R1079 VSS.n288 VSS.n128 0.0755
R1080 VSS.n286 VSS.n133 0.0755
R1081 VSS.n279 VSS.n133 0.0755
R1082 VSS.n276 VSS.n275 0.0755
R1083 VSS.n268 VSS.n142 0.0755
R1084 VSS.n268 VSS.n267 0.0755
R1085 VSS.n267 VSS.n143 0.0755
R1086 VSS.n260 VSS.n143 0.0755
R1087 VSS.n260 VSS.n259 0.0755
R1088 VSS.n252 VSS.n151 0.0755
R1089 VSS.n252 VSS.n251 0.0755
R1090 VSS.n251 VSS.n152 0.0755
R1091 VSS.n244 VSS.n152 0.0755
R1092 VSS.n235 VSS.n162 0.0755
R1093 VSS.n235 VSS.n234 0.0755
R1094 VSS.n234 VSS.n163 0.0755
R1095 VSS.n229 VSS.n163 0.0755
R1096 VSS.n229 VSS.n228 0.0755
R1097 VSS.n228 VSS.n166 0.0755
R1098 VSS.n221 VSS.n166 0.0755
R1099 VSS.n221 VSS.n220 0.0755
R1100 VSS.n220 VSS.n170 0.0755
R1101 VSS.n213 VSS.n170 0.0755
R1102 VSS.n211 VSS.n175 0.0755
R1103 VSS.n204 VSS.n175 0.0755
R1104 VSS.n204 VSS.n203 0.0755
R1105 VSS.n203 VSS.n179 0.0755
R1106 VSS.n196 VSS.n179 0.0755
R1107 VSS.n196 VSS.n195 0.0755
R1108 VSS.n195 VSS.n184 0.0755
R1109 VSS.n189 VSS.n184 0.0755
R1110 VSS.n189 VSS.n188 0.0755
R1111 VSS.n188 VSS.n187 0.0755
R1112 VSS.n495 VSS.n494 0.0755
R1113 VSS.n495 VSS.n88 0.0755
R1114 VSS.n502 VSS.n88 0.0755
R1115 VSS.n503 VSS.n502 0.0755
R1116 VSS.n503 VSS.n84 0.0755
R1117 VSS.n510 VSS.n84 0.0755
R1118 VSS.n511 VSS.n510 0.0755
R1119 VSS.n511 VSS.n80 0.0755
R1120 VSS.n518 VSS.n80 0.0755
R1121 VSS.n519 VSS.n518 0.0755
R1122 VSS.n519 VSS.n76 0.0755
R1123 VSS.n526 VSS.n76 0.0755
R1124 VSS.n527 VSS.n526 0.0755
R1125 VSS.n527 VSS.n72 0.0755
R1126 VSS.n534 VSS.n72 0.0755
R1127 VSS.n535 VSS.n534 0.0755
R1128 VSS.n535 VSS.n68 0.0755
R1129 VSS.n542 VSS.n68 0.0755
R1130 VSS.n543 VSS.n542 0.0755
R1131 VSS.n543 VSS.n64 0.0755
R1132 VSS.n550 VSS.n64 0.0755
R1133 VSS.n551 VSS.n550 0.0755
R1134 VSS.n551 VSS.n60 0.0755
R1135 VSS.n558 VSS.n60 0.0755
R1136 VSS.n560 VSS.n558 0.0755
R1137 VSS.n560 VSS.n559 0.0755
R1138 VSS.n559 VSS.n56 0.0755
R1139 VSS.n567 VSS.n56 0.0755
R1140 VSS.n569 VSS.n567 0.0755
R1141 VSS.n569 VSS.n568 0.0755
R1142 VSS.n568 VSS.n52 0.0755
R1143 VSS.n707 VSS.n53 0.0755
R1144 VSS.n701 VSS.n53 0.0755
R1145 VSS.n701 VSS.n700 0.0755
R1146 VSS.n700 VSS.n578 0.0755
R1147 VSS.n693 VSS.n578 0.0755
R1148 VSS.n693 VSS.n692 0.0755
R1149 VSS.n692 VSS.n582 0.0755
R1150 VSS.n685 VSS.n582 0.0755
R1151 VSS.n685 VSS.n684 0.0755
R1152 VSS.n684 VSS.n586 0.0755
R1153 VSS.n677 VSS.n586 0.0755
R1154 VSS.n677 VSS.n676 0.0755
R1155 VSS.n676 VSS.n590 0.0755
R1156 VSS.n669 VSS.n590 0.0755
R1157 VSS.n669 VSS.n668 0.0755
R1158 VSS.n668 VSS.n594 0.0755
R1159 VSS.n661 VSS.n594 0.0755
R1160 VSS.n661 VSS.n660 0.0755
R1161 VSS.n660 VSS.n598 0.0755
R1162 VSS.n653 VSS.n598 0.0755
R1163 VSS.n653 VSS.n652 0.0755
R1164 VSS.n652 VSS.n602 0.0755
R1165 VSS.n645 VSS.n602 0.0755
R1166 VSS.n645 VSS.n644 0.0755
R1167 VSS.n644 VSS.n606 0.0755
R1168 VSS.n637 VSS.n606 0.0755
R1169 VSS.n637 VSS.n636 0.0755
R1170 VSS.n636 VSS.n610 0.0755
R1171 VSS.n629 VSS.n610 0.0755
R1172 VSS.n629 VSS.n628 0.0755
R1173 VSS.n628 VSS.n614 0.0755
R1174 VSS.n621 VSS.n614 0.0755
R1175 VSS.n621 VSS.n620 0.0755
R1176 VSS.n566 VSS.n565 0.0755
R1177 VSS.n706 VSS.n574 0.0755
R1178 VSS.n307 VSS.n306 0.0755
R1179 VSS.n231 VSS.n230 0.0755
R1180 VSS.n190 VSS.n186 0.0755
R1181 VSS.n186 VSS.n0 0.0755
R1182 VSS.n816 VSS.n3 0.07175
R1183 VSS.n434 VSS.n397 0.068
R1184 VSS.n123 VSS.n121 0.068
R1185 VSS.n428 VSS.n398 0.0665
R1186 VSS.n427 VSS.n400 0.0665
R1187 VSS.n424 VSS.n423 0.0665
R1188 VSS.n419 VSS.n402 0.0665
R1189 VSS.n418 VSS.n417 0.0665
R1190 VSS.n493 VSS.n492 0.0665
R1191 VSS.n496 VSS.n91 0.0665
R1192 VSS.n497 VSS.n89 0.0665
R1193 VSS.n501 VSS.n500 0.0665
R1194 VSS.n504 VSS.n87 0.0665
R1195 VSS.n505 VSS.n85 0.0665
R1196 VSS.n509 VSS.n508 0.0665
R1197 VSS.n512 VSS.n83 0.0665
R1198 VSS.n513 VSS.n81 0.0665
R1199 VSS.n517 VSS.n516 0.0665
R1200 VSS.n520 VSS.n79 0.0665
R1201 VSS.n521 VSS.n77 0.0665
R1202 VSS.n525 VSS.n524 0.0665
R1203 VSS.n528 VSS.n75 0.0665
R1204 VSS.n529 VSS.n73 0.0665
R1205 VSS.n533 VSS.n532 0.0665
R1206 VSS.n536 VSS.n71 0.0665
R1207 VSS.n537 VSS.n69 0.0665
R1208 VSS.n541 VSS.n540 0.0665
R1209 VSS.n544 VSS.n67 0.0665
R1210 VSS.n545 VSS.n65 0.0665
R1211 VSS.n549 VSS.n548 0.0665
R1212 VSS.n552 VSS.n63 0.0665
R1213 VSS.n553 VSS.n61 0.0665
R1214 VSS.n557 VSS.n556 0.0665
R1215 VSS.n561 VSS.n59 0.0665
R1216 VSS.n562 VSS.n57 0.0665
R1217 VSS.n565 VSS.n564 0.0665
R1218 VSS.n412 VSS.n404 0.0605
R1219 VSS.n411 VSS.n408 0.0605
R1220 VSS.n409 VSS.n44 0.0605
R1221 VSS.n414 VSS.n413 0.0605
R1222 VSS.n751 VSS.n750 0.0605
R1223 VSS.n287 VSS.n286 0.0605
R1224 VSS.n151 VSS.n147 0.0605
R1225 VSS.n570 VSS.n55 0.0605
R1226 VSS.n571 VSS.n54 0.0605
R1227 VSS.n574 VSS.n573 0.0605
R1228 VSS.n436 VSS.n396 0.0595625
R1229 VSS.n720 VSS.n45 0.05675
R1230 VSS.n279 VSS.n46 0.05675
R1231 VSS.n708 VSS.n52 0.05675
R1232 VSS VSS.n0 0.054875
R1233 VSS.n723 VSS.n722 0.0535625
R1234 VSS.n431 VSS.n430 0.053
R1235 VSS.n755 VSS.n754 0.053
R1236 VSS.n305 VSS.n304 0.053
R1237 VSS.n275 VSS.n137 0.053
R1238 VSS.n244 VSS.n243 0.053
R1239 VSS.n333 VSS.n332 0.0515
R1240 VSS.n330 VSS.n109 0.0515
R1241 VSS.n329 VSS.n111 0.0515
R1242 VSS.n326 VSS.n325 0.0515
R1243 VSS.n322 VSS.n114 0.0515
R1244 VSS.n321 VSS.n116 0.0515
R1245 VSS.n317 VSS.n316 0.0515
R1246 VSS.n313 VSS.n118 0.0515
R1247 VSS.n312 VSS.n120 0.0515
R1248 VSS.n309 VSS.n308 0.0515
R1249 VSS.n705 VSS.n575 0.04925
R1250 VSS.n703 VSS.n702 0.04925
R1251 VSS.n699 VSS.n577 0.04925
R1252 VSS.n698 VSS.n579 0.04925
R1253 VSS.n695 VSS.n694 0.04925
R1254 VSS.n691 VSS.n581 0.04925
R1255 VSS.n690 VSS.n583 0.04925
R1256 VSS.n687 VSS.n686 0.04925
R1257 VSS.n683 VSS.n585 0.04925
R1258 VSS.n682 VSS.n587 0.04925
R1259 VSS.n679 VSS.n678 0.04925
R1260 VSS.n675 VSS.n589 0.04925
R1261 VSS.n674 VSS.n591 0.04925
R1262 VSS.n671 VSS.n670 0.04925
R1263 VSS.n667 VSS.n593 0.04925
R1264 VSS.n666 VSS.n595 0.04925
R1265 VSS.n663 VSS.n662 0.04925
R1266 VSS.n659 VSS.n597 0.04925
R1267 VSS.n658 VSS.n599 0.04925
R1268 VSS.n655 VSS.n654 0.04925
R1269 VSS.n651 VSS.n601 0.04925
R1270 VSS.n650 VSS.n603 0.04925
R1271 VSS.n647 VSS.n646 0.04925
R1272 VSS.n643 VSS.n605 0.04925
R1273 VSS.n642 VSS.n607 0.04925
R1274 VSS.n639 VSS.n638 0.04925
R1275 VSS.n635 VSS.n609 0.04925
R1276 VSS.n634 VSS.n611 0.04925
R1277 VSS.n631 VSS.n630 0.04925
R1278 VSS.n627 VSS.n613 0.04925
R1279 VSS.n626 VSS.n615 0.04925
R1280 VSS.n623 VSS.n622 0.04925
R1281 VSS.n619 VSS.n617 0.04925
R1282 VSS.n456 VSS.n455 0.0485
R1283 VSS.n453 VSS.n385 0.0485
R1284 VSS.n452 VSS.n387 0.0485
R1285 VSS.n449 VSS.n448 0.0485
R1286 VSS.n445 VSS.n390 0.0485
R1287 VSS.n444 VSS.n392 0.0485
R1288 VSS.n441 VSS.n440 0.0485
R1289 VSS.n438 VSS.n394 0.0485
R1290 VSS.n726 VSS.n725 0.047
R1291 VSS.n728 VSS.n43 0.047
R1292 VSS.n729 VSS.n41 0.047
R1293 VSS.n488 VSS.n369 0.045875
R1294 VSS.n486 VSS.n485 0.045875
R1295 VSS.n482 VSS.n371 0.045875
R1296 VSS.n481 VSS.n373 0.045875
R1297 VSS.n478 VSS.n477 0.045875
R1298 VSS.n474 VSS.n375 0.045875
R1299 VSS.n473 VSS.n377 0.045875
R1300 VSS.n470 VSS.n469 0.045875
R1301 VSS.n466 VSS.n379 0.045875
R1302 VSS.n465 VSS.n381 0.045875
R1303 VSS.n462 VSS.n461 0.045875
R1304 VSS.n458 VSS.n383 0.045875
R1305 VSS.n457 VSS.n456 0.045875
R1306 VSS.n422 VSS.n421 0.045875
R1307 VSS.n366 VSS.n93 0.045875
R1308 VSS.n364 VSS.n363 0.045875
R1309 VSS.n360 VSS.n95 0.045875
R1310 VSS.n359 VSS.n97 0.045875
R1311 VSS.n356 VSS.n355 0.045875
R1312 VSS.n352 VSS.n99 0.045875
R1313 VSS.n351 VSS.n101 0.045875
R1314 VSS.n348 VSS.n347 0.045875
R1315 VSS.n344 VSS.n103 0.045875
R1316 VSS.n343 VSS.n105 0.045875
R1317 VSS.n340 VSS.n339 0.045875
R1318 VSS.n336 VSS.n107 0.045875
R1319 VSS.n319 VSS.n318 0.0455
R1320 VSS.n335 VSS.n334 0.0455
R1321 VSS.n735 VSS.n734 0.044
R1322 VSS.n738 VSS.n39 0.044
R1323 VSS.n740 VSS.n739 0.044
R1324 VSS.n749 VSS.n36 0.044
R1325 VSS.n748 VSS.n37 0.044
R1326 VSS.n746 VSS.n745 0.044
R1327 VSS.n743 VSS.n32 0.0425
R1328 VSS.n757 VSS.n756 0.0425
R1329 VSS.n760 VSS.n31 0.0425
R1330 VSS.n761 VSS.n29 0.0425
R1331 VSS.n766 VSS.n765 0.0425
R1332 VSS.n768 VSS.n27 0.0425
R1333 VSS.n306 VSS.n122 0.0425
R1334 VSS.n302 VSS.n301 0.0425
R1335 VSS.n298 VSS.n125 0.0425
R1336 VSS.n297 VSS.n127 0.0425
R1337 VSS.n294 VSS.n293 0.0425
R1338 VSS.n290 VSS.n129 0.0425
R1339 VSS.n289 VSS.n131 0.0425
R1340 VSS.n285 VSS.n284 0.0425
R1341 VSS.n281 VSS.n134 0.0425
R1342 VSS.n280 VSS.n278 0.0425
R1343 VSS.n277 VSS.n136 0.0425
R1344 VSS.n274 VSS.n273 0.0425
R1345 VSS.n270 VSS.n138 0.0425
R1346 VSS.n269 VSS.n141 0.0425
R1347 VSS.n266 VSS.n265 0.0425
R1348 VSS.n262 VSS.n144 0.0425
R1349 VSS.n261 VSS.n146 0.0425
R1350 VSS.n258 VSS.n257 0.0425
R1351 VSS.n254 VSS.n148 0.0425
R1352 VSS.n253 VSS.n150 0.0425
R1353 VSS.n250 VSS.n249 0.0425
R1354 VSS.n246 VSS.n153 0.0425
R1355 VSS.n245 VSS.n155 0.0425
R1356 VSS.n241 VSS.n240 0.0425
R1357 VSS.n237 VSS.n159 0.0425
R1358 VSS.n236 VSS.n161 0.0425
R1359 VSS.n233 VSS.n232 0.0425
R1360 VSS.n722 VSS.n721 0.0423125
R1361 VSS.n770 VSS.n24 0.041
R1362 VSS.n774 VSS.n773 0.041
R1363 VSS.n777 VSS.n23 0.041
R1364 VSS.n778 VSS.n21 0.041
R1365 VSS.n782 VSS.n781 0.041
R1366 VSS.n785 VSS.n19 0.041
R1367 VSS.n786 VSS.n16 0.041
R1368 VSS.n791 VSS.n790 0.041
R1369 VSS.n794 VSS.n14 0.041
R1370 VSS.n795 VSS.n12 0.041
R1371 VSS.n799 VSS.n798 0.041
R1372 VSS.n802 VSS.n10 0.041
R1373 VSS.n803 VSS.n7 0.041
R1374 VSS.n808 VSS.n807 0.041
R1375 VSS.n810 VSS.n5 0.041
R1376 VSS.n230 VSS.n164 0.041
R1377 VSS.n227 VSS.n226 0.041
R1378 VSS.n223 VSS.n167 0.041
R1379 VSS.n222 VSS.n169 0.041
R1380 VSS.n219 VSS.n218 0.041
R1381 VSS.n215 VSS.n171 0.041
R1382 VSS.n214 VSS.n173 0.041
R1383 VSS.n210 VSS.n209 0.041
R1384 VSS.n206 VSS.n176 0.041
R1385 VSS.n205 VSS.n178 0.041
R1386 VSS.n202 VSS.n201 0.041
R1387 VSS.n198 VSS.n180 0.041
R1388 VSS.n197 VSS.n182 0.041
R1389 VSS.n194 VSS.n193 0.041
R1390 VSS.n191 VSS.n185 0.041
R1391 VSS.n753 VSS.n30 0.038
R1392 VSS.n762 VSS.n30 0.038
R1393 VSS.n788 VSS.n787 0.038
R1394 VSS.n789 VSS.n788 0.038
R1395 VSS.n815 VSS.n814 0.038
R1396 VSS.n242 VSS.n158 0.038
R1397 VSS.n162 VSS.n158 0.038
R1398 VSS.n213 VSS.n212 0.038
R1399 VSS.n212 VSS.n211 0.038
R1400 VSS.n187 VSS.n1 0.038
R1401 VSS.n773 VSS.n24 0.035
R1402 VSS.n774 VSS.n23 0.035
R1403 VSS.n778 VSS.n777 0.035
R1404 VSS.n781 VSS.n21 0.035
R1405 VSS.n782 VSS.n19 0.035
R1406 VSS.n786 VSS.n785 0.035
R1407 VSS.n790 VSS.n16 0.035
R1408 VSS.n791 VSS.n14 0.035
R1409 VSS.n795 VSS.n794 0.035
R1410 VSS.n798 VSS.n12 0.035
R1411 VSS.n799 VSS.n10 0.035
R1412 VSS.n803 VSS.n802 0.035
R1413 VSS.n807 VSS.n7 0.035
R1414 VSS.n808 VSS.n5 0.035
R1415 VSS.n811 VSS.n810 0.035
R1416 VSS.n227 VSS.n164 0.035
R1417 VSS.n226 VSS.n167 0.035
R1418 VSS.n223 VSS.n222 0.035
R1419 VSS.n219 VSS.n169 0.035
R1420 VSS.n218 VSS.n171 0.035
R1421 VSS.n215 VSS.n214 0.035
R1422 VSS.n210 VSS.n173 0.035
R1423 VSS.n209 VSS.n176 0.035
R1424 VSS.n206 VSS.n205 0.035
R1425 VSS.n202 VSS.n178 0.035
R1426 VSS.n201 VSS.n180 0.035
R1427 VSS.n198 VSS.n197 0.035
R1428 VSS.n194 VSS.n182 0.035
R1429 VSS.n193 VSS.n185 0.035
R1430 VSS.n191 VSS.n190 0.035
R1431 VSS.n719 VSS.n46 0.034157
R1432 VSS.n720 VSS.n719 0.034157
R1433 VSS.n756 VSS.n32 0.0335
R1434 VSS.n757 VSS.n31 0.0335
R1435 VSS.n761 VSS.n760 0.0335
R1436 VSS.n765 VSS.n29 0.0335
R1437 VSS.n766 VSS.n27 0.0335
R1438 VSS.n769 VSS.n768 0.0335
R1439 VSS.n302 VSS.n122 0.0335
R1440 VSS.n301 VSS.n125 0.0335
R1441 VSS.n298 VSS.n297 0.0335
R1442 VSS.n294 VSS.n127 0.0335
R1443 VSS.n293 VSS.n129 0.0335
R1444 VSS.n290 VSS.n289 0.0335
R1445 VSS.n285 VSS.n131 0.0335
R1446 VSS.n284 VSS.n134 0.0335
R1447 VSS.n281 VSS.n280 0.0335
R1448 VSS.n278 VSS.n277 0.0335
R1449 VSS.n274 VSS.n136 0.0335
R1450 VSS.n273 VSS.n138 0.0335
R1451 VSS.n270 VSS.n269 0.0335
R1452 VSS.n266 VSS.n141 0.0335
R1453 VSS.n265 VSS.n144 0.0335
R1454 VSS.n262 VSS.n261 0.0335
R1455 VSS.n258 VSS.n146 0.0335
R1456 VSS.n257 VSS.n148 0.0335
R1457 VSS.n254 VSS.n253 0.0335
R1458 VSS.n250 VSS.n150 0.0335
R1459 VSS.n249 VSS.n153 0.0335
R1460 VSS.n246 VSS.n245 0.0335
R1461 VSS.n241 VSS.n155 0.0335
R1462 VSS.n240 VSS.n159 0.0335
R1463 VSS.n237 VSS.n236 0.0335
R1464 VSS.n233 VSS.n161 0.0335
R1465 VSS.n232 VSS.n231 0.0335
R1466 VSS.n734 VSS.n733 0.032
R1467 VSS.n735 VSS.n39 0.032
R1468 VSS.n740 VSS.n738 0.032
R1469 VSS.n739 VSS.n36 0.032
R1470 VSS.n749 VSS.n748 0.032
R1471 VSS.n746 VSS.n37 0.032
R1472 VSS.n320 VSS.n319 0.0305
R1473 VSS.n486 VSS.n369 0.030125
R1474 VSS.n485 VSS.n371 0.030125
R1475 VSS.n482 VSS.n481 0.030125
R1476 VSS.n478 VSS.n373 0.030125
R1477 VSS.n477 VSS.n375 0.030125
R1478 VSS.n474 VSS.n473 0.030125
R1479 VSS.n470 VSS.n377 0.030125
R1480 VSS.n469 VSS.n379 0.030125
R1481 VSS.n466 VSS.n465 0.030125
R1482 VSS.n462 VSS.n381 0.030125
R1483 VSS.n461 VSS.n383 0.030125
R1484 VSS.n458 VSS.n457 0.030125
R1485 VSS.n421 VSS.n420 0.030125
R1486 VSS.n364 VSS.n93 0.030125
R1487 VSS.n363 VSS.n95 0.030125
R1488 VSS.n360 VSS.n359 0.030125
R1489 VSS.n356 VSS.n97 0.030125
R1490 VSS.n355 VSS.n99 0.030125
R1491 VSS.n352 VSS.n351 0.030125
R1492 VSS.n348 VSS.n101 0.030125
R1493 VSS.n347 VSS.n103 0.030125
R1494 VSS.n344 VSS.n343 0.030125
R1495 VSS.n340 VSS.n105 0.030125
R1496 VSS.n339 VSS.n107 0.030125
R1497 VSS.n336 VSS.n335 0.030125
R1498 VSS.n726 VSS.n43 0.029
R1499 VSS.n729 VSS.n728 0.029
R1500 VSS.n732 VSS.n41 0.029
R1501 VSS.n455 VSS.n385 0.0275
R1502 VSS.n453 VSS.n452 0.0275
R1503 VSS.n449 VSS.n387 0.0275
R1504 VSS.n448 VSS.n390 0.0275
R1505 VSS.n445 VSS.n444 0.0275
R1506 VSS.n441 VSS.n392 0.0275
R1507 VSS.n440 VSS.n394 0.0275
R1508 VSS.n438 VSS.n437 0.0275
R1509 VSS.n706 VSS.n705 0.02675
R1510 VSS.n703 VSS.n575 0.02675
R1511 VSS.n702 VSS.n577 0.02675
R1512 VSS.n699 VSS.n698 0.02675
R1513 VSS.n695 VSS.n579 0.02675
R1514 VSS.n694 VSS.n581 0.02675
R1515 VSS.n691 VSS.n690 0.02675
R1516 VSS.n687 VSS.n583 0.02675
R1517 VSS.n686 VSS.n585 0.02675
R1518 VSS.n683 VSS.n682 0.02675
R1519 VSS.n679 VSS.n587 0.02675
R1520 VSS.n678 VSS.n589 0.02675
R1521 VSS.n675 VSS.n674 0.02675
R1522 VSS.n671 VSS.n591 0.02675
R1523 VSS.n670 VSS.n593 0.02675
R1524 VSS.n667 VSS.n666 0.02675
R1525 VSS.n663 VSS.n595 0.02675
R1526 VSS.n662 VSS.n597 0.02675
R1527 VSS.n659 VSS.n658 0.02675
R1528 VSS.n655 VSS.n599 0.02675
R1529 VSS.n654 VSS.n601 0.02675
R1530 VSS.n651 VSS.n650 0.02675
R1531 VSS.n647 VSS.n603 0.02675
R1532 VSS.n646 VSS.n605 0.02675
R1533 VSS.n643 VSS.n642 0.02675
R1534 VSS.n639 VSS.n607 0.02675
R1535 VSS.n638 VSS.n609 0.02675
R1536 VSS.n635 VSS.n634 0.02675
R1537 VSS.n631 VSS.n611 0.02675
R1538 VSS.n630 VSS.n613 0.02675
R1539 VSS.n627 VSS.n626 0.02675
R1540 VSS.n623 VSS.n615 0.02675
R1541 VSS.n622 VSS.n617 0.02675
R1542 VSS.n619 VSS.n618 0.02675
R1543 VSS.n332 VSS.n109 0.0245
R1544 VSS.n330 VSS.n329 0.0245
R1545 VSS.n326 VSS.n111 0.0245
R1546 VSS.n325 VSS.n114 0.0245
R1547 VSS.n322 VSS.n321 0.0245
R1548 VSS.n317 VSS.n116 0.0245
R1549 VSS.n316 VSS.n118 0.0245
R1550 VSS.n313 VSS.n312 0.0245
R1551 VSS.n309 VSS.n120 0.0245
R1552 VSS.n308 VSS.n307 0.0245
R1553 VSS.n430 VSS.n429 0.023
R1554 VSS.n730 VSS.n42 0.023
R1555 VSS.n754 VSS.n753 0.023
R1556 VSS.n304 VSS.n303 0.023
R1557 VSS.n142 VSS.n137 0.023
R1558 VSS.n243 VSS.n242 0.023
R1559 VSS.n724 VSS.n723 0.0224375
R1560 VSS.n724 VSS.n720 0.01925
R1561 VSS.n276 VSS.n46 0.01925
R1562 VSS.n708 VSS.n707 0.01925
R1563 VSS VSS.n818 0.017375
R1564 VSS.n396 VSS.n393 0.0164375
R1565 VSS.n416 VSS.n404 0.0155
R1566 VSS.n412 VSS.n411 0.0155
R1567 VSS.n409 VSS.n408 0.0155
R1568 VSS.n415 VSS.n414 0.0155
R1569 VSS.n751 VSS.n34 0.0155
R1570 VSS.n288 VSS.n287 0.0155
R1571 VSS.n259 VSS.n147 0.0155
R1572 VSS.n566 VSS.n55 0.0155
R1573 VSS.n571 VSS.n570 0.0155
R1574 VSS.n573 VSS.n54 0.0155
R1575 VSS.n721 VSS.n42 0.0111875
R1576 VSS.n432 VSS.n398 0.0095
R1577 VSS.n428 VSS.n427 0.0095
R1578 VSS.n424 VSS.n400 0.0095
R1579 VSS.n423 VSS.n402 0.0095
R1580 VSS.n419 VSS.n418 0.0095
R1581 VSS.n493 VSS.n91 0.0095
R1582 VSS.n497 VSS.n496 0.0095
R1583 VSS.n500 VSS.n89 0.0095
R1584 VSS.n501 VSS.n87 0.0095
R1585 VSS.n505 VSS.n504 0.0095
R1586 VSS.n508 VSS.n85 0.0095
R1587 VSS.n509 VSS.n83 0.0095
R1588 VSS.n513 VSS.n512 0.0095
R1589 VSS.n516 VSS.n81 0.0095
R1590 VSS.n517 VSS.n79 0.0095
R1591 VSS.n521 VSS.n520 0.0095
R1592 VSS.n524 VSS.n77 0.0095
R1593 VSS.n525 VSS.n75 0.0095
R1594 VSS.n529 VSS.n528 0.0095
R1595 VSS.n532 VSS.n73 0.0095
R1596 VSS.n533 VSS.n71 0.0095
R1597 VSS.n537 VSS.n536 0.0095
R1598 VSS.n540 VSS.n69 0.0095
R1599 VSS.n541 VSS.n67 0.0095
R1600 VSS.n545 VSS.n544 0.0095
R1601 VSS.n548 VSS.n65 0.0095
R1602 VSS.n549 VSS.n63 0.0095
R1603 VSS.n553 VSS.n552 0.0095
R1604 VSS.n556 VSS.n61 0.0095
R1605 VSS.n557 VSS.n59 0.0095
R1606 VSS.n562 VSS.n561 0.0095
R1607 VSS.n564 VSS.n57 0.0095
R1608 VSS.n431 VSS.n397 0.008
R1609 VSS.n305 VSS.n123 0.008
R1610 VSS.n334 VSS.n333 0.000875
C0 t2 vgr 0
C1 t2 nb 2.83595f
C2 vgr g2p 0.18549f
C3 nb g2p 0.07889f
C4 t3 g3p 2.91775f
C5 o2p o1p 0.17851f
C6 VDD mRp2b 1.27896f
C7 outp mRp3a 2.19053f
C8 o2n t3 0.30481f
C9 VDD g2n 1.86961f
C10 o2p vb 1.28735f
C11 o1n o1p 6.02565f
C12 inp outn 0.01544f
C13 g3n outn 0.10389f
C14 outp vgr 0.90342f
C15 outp nb 0.51471f
C16 VDD mRp3b 0.14807f
C17 o1n vb 0.18862f
C18 g2p mRp2a 2.71538f
C19 inn g2p 0.02671f
C20 g2n inp 0.02054f
C21 t1 outn 0.00386f
C22 vgr vbt 0.08774f
C23 enb o1p 0.20141f
C24 g3p outn 3.04668f
C25 o2p o1n 0.37415f
C26 t3 nb 2.98191f
C27 VDD o1p 1.62523f
C28 o2n outn 1.58613f
C29 g3n mRp3b 0.50302f
C30 t2 g2p 2.90297f
C31 VDD vb 5.57491f
C32 t1 g2n 0.01151f
C33 o2n mRp2b 0.00107f
C34 g2n g3p 0.00924f
C35 o2n g2n 0.63356f
C36 enb o2p 0.79409f
C37 vbt mRp2a 0.00601f
C38 mRp3a outn 0.00909f
C39 o1p inp 0.43338f
C40 g3p mRp3b 0.14588f
C41 VDD o2p 2.44017f
C42 outp t2 0.47994f
C43 vbt inn 0.00951f
C44 outp g2p 0.10829f
C45 enb o1n 0.32203f
C46 vgr outn 6.2003f
C47 nb outn 2.71045f
C48 vb g3n 0.60573f
C49 VDD o1n 1.55489f
C50 t1 o1p 10.4824f
C51 vgr mRp2b 0.00978f
C52 vbt g2p 1.35765f
C53 t2 t3 0.00372f
C54 o2p inp 1.07262f
C55 vgr g2n 1.6135f
C56 o2n o1p 0.0821f
C57 nb g2n 0.07879f
C58 o2p g3n 0.19553f
C59 mRp3a mRp3b 0.08704f
C60 vb g3p 0.83647f
C61 enb VDD 4.21057f
C62 o2n vb 0.35264f
C63 o1n inp 9.18763f
C64 vgr mRp3b 0.0027f
C65 inn outn 0.01688f
C66 t1 o2p 0.41474f
C67 outp t3 0.49853f
C68 o2p g3p 5.93947f
C69 mRp2b mRp2a 0.14576f
C70 o2p o2n 4.9399f
C71 g2n mRp2a 0.13427f
C72 t1 o1n 10.899f
C73 vgr o1p 0.31673f
C74 enb inp 0.39919f
C75 t2 outn 1.43221f
C76 mRp3a vb 0.68743f
C77 o1p nb 0
C78 inn g2n 0.02783f
C79 g2p outn 0.23654f
C80 o2n o1n 0.38655f
C81 VDD inp 0.37885f
C82 VDD g3n 3.79046f
C83 vgr vb 8.98949f
C84 vb nb 2.55563f
C85 mRp2b g2p 0.62517f
C86 o2p mRp3a 0.03426f
C87 t2 g2n 2.93218f
C88 enb t1 0.21873f
C89 g2n g2p 4.72021f
C90 outp outn 5.59053f
C91 o2p vgr 0.23215f
C92 VDD t1 0.46805f
C93 o2p nb 0.04002f
C94 enb o2n 0.78638f
C95 VDD g3p 4.33045f
C96 VDD o2n 1.74896f
C97 inn o1p 15.6107f
C98 vgr o1n 2.7789f
C99 o1n nb 0.02579f
C100 vb mRp2a 3.04322f
C101 outp g2n 0.06647f
C102 t3 outn 0.87498f
C103 t1 inp 15.0185f
C104 outp mRp3b 1.22474f
C105 o1p g2p 4.53819f
C106 g3n g3p 0.34872f
C107 o2p mRp2a 0.02666f
C108 VDD mRp3a 0.1197f
C109 o2n inp 1.03194f
C110 o2n g3n 6.81759f
C111 o2p inn 1.11701f
C112 vb g2p 0.66867f
C113 VDD vgr 8.69912f
C114 VDD nb 0.0724f
C115 o1n mRp2a 0.04266f
C116 o1n inn 0.54853f
C117 t1 o2n 0.48555f
C118 o2p t2 0.3005f
C119 o2n g3p 0.12772f
C120 o2p g2p 2.6676f
C121 mRp3a g3n 0.1479f
C122 outp vb 1.61419f
C123 vgr inp 0.00137f
C124 vbt o1p 1.6832f
C125 nb inp 0.00158f
C126 o1n g2p 2.57561f
C127 vgr g3n 0.06347f
C128 g3n nb 0.27085f
C129 enb inn 0.32081f
C130 VDD mRp2a 0.04832f
C131 g2n outn 0.17948f
C132 outp o2p 0.29088f
C133 VDD inn 0.09959f
C134 vbt vb 0.28747f
C135 mRp3a g3p 2.77518f
C136 vb t3 0.14106f
C137 mRp2b g2n 0.62129f
C138 t1 vgr 0.03745f
C139 t1 nb 0.70522f
C140 vgr g3p 0.17684f
C141 nb g3p 0.17164f
C142 enb g2p 0.00127f
C143 vgr o2n 1.51266f
C144 o2n nb 0.53721f
C145 VDD g2p 2.40668f
C146 o2p t3 0
C147 inn inp 5.36931f
C148 vbt o1n 1.19688f
C149 o1p outn 0.00139f
C150 outp VDD 0.82022f
C151 vb outn 0.33016f
C152 vgr mRp3a 0.05207f
C153 t2 g3n 0
C154 g2p inp 0.01844f
C155 t1 inn 15.1293f
C156 o1p g2n 0.02964f
C157 enb vbt 0.62326f
C158 o2n inn 0.99043f
C159 vgr nb 2.2874f
C160 mRp2b vb 0.57255f
C161 o2p outn 1.56807f
C162 VDD vbt 1.66707f
C163 vb g2n 0.51815f
C164 t1 t2 0.003f
C165 t2 g3p 0.01189f
C166 t1 g2p 0.01205f
C167 outp g3n 3.27704f
C168 g2p g3p 0.01549f
C169 o1n outn 0.00225f
C170 o2p mRp2b 0.58102f
C171 t2 o2n 0.56895f
C172 o2n g2p 3.24838f
C173 vb mRp3b 0.42363f
C174 o2p g2n 4.3121f
C175 vgr mRp2a 0.05312f
C176 vbt inp 0.00152f
C177 outp g3p 1.08101f
C178 inn nb 0
C179 o1n g2n 6.65711f
C180 g3n t3 2.927f
C181 outp o2n 2.54324f
C182 vb o1p 0.14015f
C183 VDD outn 0.78967f
C184 t1 vbt 0.00159f
C185 nb VSS 15.5547f
C186 inn VSS 2.38457f
C187 inp VSS 2.6734f
C188 enb VSS 2.72347f
C189 outp VSS 14.7893f
C190 outn VSS 12.9939f
C191 VDD VSS 62.9977f
C192 t3 VSS 2.88763f
C193 t2 VSS 2.48721f
C194 t1 VSS 4.88036f
C195 mRp3b VSS 0.70445f
C196 mRp3a VSS 0.87833f
C197 mRp2b VSS 0.92869f
C198 mRp2a VSS 0.74262f
C199 vgr VSS 14.9957f
C200 vbt VSS 1.69087f
C201 o2n VSS 68.2529f
C202 o2p VSS 65.8162f
C203 o1n VSS 48.1779f
C204 o1p VSS 42.8538f
C205 g3n VSS 8.5093f
C206 g3p VSS 7.11958f
C207 g2n VSS 8.075f
C208 g2p VSS 8.10695f
C209 vb VSS 63.1453f
C210 VDD.n0 VSS 0.122514f
C211 VDD.t1 VSS 0.067327f
C212 VDD.n1 VSS 0.2178f
C213 VDD.n2 VSS 0.108903f
C214 VDD.n3 VSS 0.119167f
C215 VDD.n4 VSS 0.2178f
C216 VDD.n5 VSS 0.132859f
C217 VDD.n6 VSS 0.2178f
C218 VDD.n7 VSS 0.108903f
C219 VDD.n8 VSS 0.2178f
C220 VDD.n9 VSS 0.108903f
C221 VDD.n10 VSS 0.2178f
C222 VDD.n11 VSS 0.108903f
C223 VDD.n12 VSS 0.576656f
C224 VDD.n13 VSS 0.108903f
C225 VDD.n14 VSS 0.2178f
C226 VDD.n15 VSS 0.117616f
C227 VDD.n16 VSS 0.2178f
C228 VDD.n17 VSS 0.108903f
C229 VDD.n18 VSS 0.2178f
C230 VDD.n19 VSS 0.108903f
C231 VDD.n20 VSS 0.2178f
C232 VDD.n21 VSS 0.108903f
C233 VDD.n22 VSS 0.0602f
C234 VDD.n23 VSS 0.2178f
C235 VDD.n24 VSS 0.108903f
C236 VDD.n25 VSS 0.2178f
C237 VDD.n26 VSS 0.108903f
C238 VDD.n27 VSS 0.2178f
C239 VDD.n28 VSS 0.108903f
C240 VDD.n29 VSS 0.1229f
C241 VDD.n30 VSS 0.2178f
C242 VDD.n31 VSS 0.108903f
C243 VDD.n32 VSS 4.65331f
C244 VDD.t0 VSS 4.05381f
C245 VDD.n33 VSS 10.1181f
C246 VDD.n34 VSS 0.2178f
C247 VDD.n35 VSS 0.239459f
C248 VDD.n36 VSS 0.108903f
C249 VDD.n37 VSS 0.108903f
C250 VDD.n38 VSS 0.640962f
C251 VDD.n39 VSS 0.116681f
C252 VDD.n40 VSS 0.150283f
C253 VDD.n41 VSS 0.154639f
C254 VDD.n42 VSS 0.2178f
C255 VDD.n43 VSS 0.2178f
C256 VDD.n44 VSS 0.108903f
C257 VDD.n45 VSS 0.108903f
C258 VDD.n46 VSS 0.497832f
C259 VDD.n47 VSS 0.2178f
C260 VDD.n48 VSS 0.108903f
C261 VDD.n49 VSS 0.108903f
C262 VDD.n50 VSS 0.2178f
C263 VDD.n51 VSS 0.2178f
C264 VDD.n52 VSS 0.108903f
C265 VDD.n53 VSS 0.108903f
C266 VDD.n54 VSS 0.373374f
C267 VDD.n55 VSS 0.116681f
C268 VDD.n56 VSS 0.172064f
C269 VDD.n57 VSS 0.2178f
C270 VDD.n58 VSS 0.2178f
C271 VDD.n59 VSS 0.2178f
C272 VDD.n60 VSS 0.0748334f
C273 VDD.n61 VSS 0.119377f
C274 VDD.n62 VSS 0.427308f
C275 VDD.n63 VSS 0.108903f
C276 VDD.n64 VSS 0.108903f
C277 VDD.n65 VSS 0.2178f
C278 VDD.n66 VSS 0.2178f
C279 VDD.n67 VSS 0.108903f
C280 VDD.n68 VSS 0.108903f
C281 VDD.n69 VSS 0.108903f
C282 VDD.n70 VSS 0.2178f
C283 VDD.n71 VSS 0.373374f
C284 VDD.n72 VSS 0.116681f
C285 VDD.n73 VSS 0.108903f
C286 VDD.n74 VSS 0.2178f
C287 VDD.n75 VSS 0.2178f
C288 VDD.n76 VSS 0.2178f
C289 VDD.n77 VSS 0.2178f
C290 VDD.n78 VSS 0.193845f
C291 VDD.n79 VSS 0.126843f
C292 VDD.n80 VSS 0.108903f
C293 VDD.n81 VSS 0.2178f
C294 VDD.n82 VSS 0.2178f
C295 VDD.n83 VSS 0.108903f
C296 VDD.n84 VSS 0.108903f
C297 VDD.n85 VSS 0.2178f
C298 VDD.n86 VSS 0.2178f
C299 VDD.n87 VSS 0.108903f
C300 VDD.n88 VSS 0.108903f
C301 VDD.n89 VSS 0.2178f
C302 VDD.n90 VSS 0.2178f
C303 VDD.n91 VSS 0.108903f
C304 VDD.n92 VSS 0.108903f
C305 VDD.n93 VSS 0.108903f
C306 VDD.n94 VSS 0.2178f
C307 VDD.n95 VSS 0.373374f
C308 VDD.n96 VSS 0.116681f
C309 VDD.n97 VSS 0.108903f
C310 VDD.n98 VSS 0.2178f
C311 VDD.n99 VSS 0.2178f
C312 VDD.n100 VSS 0.2178f
C313 VDD.n101 VSS 0.2178f
C314 VDD.n102 VSS 0.0197144f
C315 VDD.t6 VSS 0.0802667f
C316 VDD.t5 VSS 0.034612f
C317 VDD.n103 VSS 0.45923f
C318 VDD.t4 VSS 0.034612f
C319 VDD.n104 VSS 0.326669f
C320 VDD.t2 VSS 0.034612f
C321 VDD.n105 VSS 0.627209f
C322 VDD.t7 VSS 0.120251f
C323 VDD.n106 VSS 0.612332f
C324 VDD.t3 VSS 0.120251f
C325 VDD.n107 VSS 0.257439f
C326 VDD.n108 VSS 0.156889f
C327 VDD.n109 VSS 0.0914788f
C328 VDD.n110 VSS 0.2178f
C329 VDD.n111 VSS 0.2178f
C330 VDD.n112 VSS 0.108903f
C331 VDD.n113 VSS 0.108903f
C332 VDD.n114 VSS 0.108903f
C333 VDD.n115 VSS 0.423162f
C334 VDD.n116 VSS -12.0955f
C335 VDD.n117 VSS -0.281591f
C336 VDD.n118 VSS 0.108903f
C337 VDD.n119 VSS 0.2178f
C338 VDD.n120 VSS 0.180505f
C339 VDD.n121 VSS 0.378543f
C340 outn.t3 VSS 2.56236f
C341 outn.t6 VSS 2.56331f
C342 outn.t5 VSS 2.52685f
C343 outn.n0 VSS 0.662052f
C344 outn.t4 VSS 2.52685f
C345 outn.n1 VSS 0.331658f
C346 outn.n2 VSS 0.413649f
C347 outn.t1 VSS 0.114753f
C348 outn.t0 VSS 0.10668f
C349 outn.n3 VSS 0.107322f
C350 outn.n4 VSS 0.223441f
C351 outn.t2 VSS 0.0107788f
C352 outn.n5 VSS 0.134858f
C353 outp.t3 VSS 2.40873f
C354 outp.t6 VSS 2.43396f
C355 outp.t5 VSS 2.40089f
C356 outp.n0 VSS 0.626703f
C357 outp.t4 VSS 2.40089f
C358 outp.n1 VSS 0.329927f
C359 outp.n2 VSS 0.403511f
C360 outp.t1 VSS 0.0107333f
C361 outp.t0 VSS 0.0107333f
C362 outp.n3 VSS 0.0938112f
C363 outp.n4 VSS 0.199103f
C364 outp.t2 VSS 0.0208137f
C365 outp.n5 VSS 0.130675f
C366 enb.t0 VSS 0.0392476f
C367 inp.t0 VSS 0.306262f
C368 inp.t1 VSS 0.304253f
C369 inp.n0 VSS 0.260221f
C370 inp.t2 VSS 0.304253f
C371 inp.n1 VSS 0.134073f
C372 inp.t3 VSS 0.304253f
C373 inp.n2 VSS 0.134073f
C374 inp.t4 VSS 0.304253f
C375 inp.n3 VSS 0.134073f
C376 inp.t5 VSS 0.304253f
C377 inp.n4 VSS 0.134073f
C378 inp.t6 VSS 0.304253f
C379 inp.n5 VSS 0.130347f
C380 inp.t15 VSS 0.306262f
C381 inp.t14 VSS 0.304253f
C382 inp.n6 VSS 0.260221f
C383 inp.t13 VSS 0.304253f
C384 inp.n7 VSS 0.134073f
C385 inp.t12 VSS 0.304253f
C386 inp.n8 VSS 0.134073f
C387 inp.t11 VSS 0.304253f
C388 inp.n9 VSS 0.134073f
C389 inp.t10 VSS 0.304253f
C390 inp.n10 VSS 0.134073f
C391 inp.t9 VSS 0.304253f
C392 inp.n11 VSS 0.134073f
C393 inp.t8 VSS 0.304253f
C394 inp.n12 VSS 0.130421f
C395 inp.t7 VSS 0.304253f
C396 inp.n13 VSS 0.112229f
C397 inp.n14 VSS 0.277578f
C398 inn.t0 VSS 0.310527f
C399 inn.t1 VSS 0.309872f
C400 inn.n0 VSS 0.269175f
C401 inn.t2 VSS 0.309872f
C402 inn.n1 VSS 0.145339f
C403 inn.t3 VSS 0.309872f
C404 inn.n2 VSS 0.145339f
C405 inn.t4 VSS 0.309872f
C406 inn.n3 VSS 0.145339f
C407 inn.t5 VSS 0.309872f
C408 inn.n4 VSS 0.145339f
C409 inn.t6 VSS 0.309872f
C410 inn.n5 VSS 0.143929f
C411 inn.t15 VSS 0.310527f
C412 inn.t14 VSS 0.309872f
C413 inn.n6 VSS 0.269175f
C414 inn.t13 VSS 0.309872f
C415 inn.n7 VSS 0.145339f
C416 inn.t12 VSS 0.309872f
C417 inn.n8 VSS 0.145339f
C418 inn.t11 VSS 0.309872f
C419 inn.n9 VSS 0.145339f
C420 inn.t10 VSS 0.309872f
C421 inn.n10 VSS 0.145339f
C422 inn.t9 VSS 0.309872f
C423 inn.n11 VSS 0.145339f
C424 inn.t8 VSS 0.309872f
C425 inn.n12 VSS 0.13421f
C426 inn.t7 VSS 0.309872f
C427 inn.n13 VSS 0.128201f
C428 inn.n14 VSS 0.271925f
C429 nb.t1 VSS 0.19463f
C430 nb.t4 VSS 0.233654f
C431 nb.t3 VSS 0.233016f
C432 nb.n0 VSS 0.464335f
C433 nb.t2 VSS 0.172678f
C434 nb.n1 VSS 0.556481f
C435 nb.n2 VSS 1.24794f
C436 nb.t0 VSS 3.32295f
C437 nb.n3 VSS 1.41725f
.ends
