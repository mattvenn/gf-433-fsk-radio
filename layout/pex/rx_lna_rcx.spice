* rx_lna: magic R+C extraction of layout/rx_lna.gds (layout/gen/pex.sh)
* rcfix.py: split-net C to VSS scaled by (S - K) / S on 9 nets (coupling double count removed)
* extracted 2026-11-15T23:54:27+01:00 with magic 8.3.642, mode rc, from rx_lna.gds
.subckt rx_lna VDD VSS inp inn oip oin oqp oqn nb enb
X0 oqp.t5 outn x2q_tail VSS.t65 nfet_03v3 ad=5p pd=11u as=5p ps=11u w=10u l=0.28u
X1 x2q_tail nb.t3 VSS.t166 VSS.t165 nfet_03v3 ad=5p pd=11u as=5p ps=11u w=10u l=0.5u
X2 outp inn.t6 tail VSS.t18 nfet_03v3 ad=5p pd=11u as=5p ps=11u w=10u l=0.28u
X3 outn inp.t7 tail VSS.t86 nfet_03v3 ad=5p pd=11u as=5p ps=11u w=10u l=0.28u
X4 outp inn.t14 tail VSS.t10 nfet_03v3 ad=5p pd=11u as=5p ps=11u w=10u l=0.28u
X5 x2q_tail nb.t5 VSS.t162 VSS.t161 nfet_03v3 ad=5p pd=11u as=5p ps=11u w=10u l=0.5u
X6 VSS.t172 nb.t0 x2q_tail VSS.t171 nfet_03v3 ad=10p pd=22u as=5p ps=11u w=10u l=0.5u
X7 outn inp.t15 tail VSS.t78 nfet_03v3 ad=5p pd=11u as=5p ps=11u w=10u l=0.28u
X8 VSS.t138 nb.t18 tail VSS.t137 nfet_03v3 ad=2.8p pd=10.56u as=5p ps=11u w=10u l=0.5u
X9 x2i_tail outp oin.t4 VSS.t29 nfet_03v3 ad=5p pd=11u as=5p ps=11u w=10u l=0.28u
X10 VSS.t134 nb.t20 tail VSS.t133 nfet_03v3 ad=2.8p pd=10.56u as=5p ps=11u w=10u l=0.5u
X11 x2i_tail outn oip.t4 VSS.t58 nfet_03v3 ad=5p pd=11u as=5p ps=11u w=10u l=0.28u
X12 VSS.t168 nb.t2 x2q_tail VSS.t167 nfet_03v3 ad=5p pd=11u as=5p ps=11u w=10u l=0.5u
X13 VSS.t158 nb.t8 tail VSS.t157 nfet_03v3 ad=4.5p pd=20.9u as=5p ps=11u w=10u l=0.5u
X14 tail inn.t3 outp VSS.t21 nfet_03v3 ad=5p pd=11u as=5p ps=11u w=10u l=0.28u
X15 tail inp.t22 outn VSS.t71 nfet_03v3 ad=5p pd=11u as=5p ps=11u w=10u l=0.28u
X16 x2i_tail nb.t33 VSS.t108 VSS.t107 nfet_03v3 ad=5p pd=11u as=2.8p ps=10.56u w=10u l=0.5u
X17 VSS.t118 nb.t28 tail VSS.t117 nfet_03v3 ad=2.8p pd=10.56u as=5p ps=11u w=10u l=0.5u
X18 oip.t0 VDD.t0 VSS.t24 ppolyf_u r_width=2u r_length=9.14u
X19 x2q_tail outn oqp.t6 VSS.t66 nfet_03v3 ad=5p pd=11u as=5p ps=11u w=10u l=0.28u
X20 tail nb.t25 VSS.t124 VSS.t123 nfet_03v3 ad=5p pd=11u as=2.8p ps=10.56u w=10u l=0.5u
X21 VSS.t114 nb.t30 tail VSS.t113 nfet_03v3 ad=2.8p pd=10.56u as=5p ps=11u w=10u l=0.5u
X22 outn inp.t11 tail VSS.t82 nfet_03v3 ad=5p pd=11u as=5p ps=11u w=10u l=0.28u
X23 outp inn.t18 tail VSS.t6 nfet_03v3 ad=5p pd=11u as=5p ps=11u w=10u l=0.28u
X24 VSS.t106 nb.t34 x2i_tail VSS.t105 nfet_03v3 ad=2.8p pd=10.56u as=5p ps=11u w=10u l=0.5u
X25 tail nb.t27 VSS.t120 VSS.t119 nfet_03v3 ad=5p pd=11u as=2.8p ps=10.56u w=10u l=0.5u
X26 tail inp.t8 outn VSS.t85 nfet_03v3 ad=5p pd=11u as=5p ps=11u w=10u l=0.28u
X27 x2q_tail outn oqp.t4 VSS.t64 nfet_03v3 ad=5p pd=11u as=5p ps=11u w=10u l=0.28u
X28 outn inp.t19 tail VSS.t74 nfet_03v3 ad=5p pd=11u as=5p ps=11u w=10u l=0.28u
X29 VSS.t102 nb.t36 x2i_tail VSS.t101 nfet_03v3 ad=2.8p pd=10.56u as=5p ps=11u w=10u l=0.5u
X30 VSS.t146 nb.t14 tail VSS.t145 nfet_03v3 ad=2.8p pd=10.56u as=5p ps=11u w=10u l=0.5u
X31 tail inn.t9 outp VSS.t15 nfet_03v3 ad=5p pd=11u as=5p ps=11u w=10u l=0.28u
X32 tail inp.t16 outn VSS.t77 nfet_03v3 ad=5p pd=11u as=5p ps=11u w=10u l=0.28u
X33 vcm inn.t0 VSS.t39 ppolyf_u_1k r_width=1u r_length=20u
X34 VSS.t142 nb.t16 tail VSS.t141 nfet_03v3 ad=2.8p pd=10.56u as=5p ps=11u w=10u l=0.5u
X35 tail inn.t17 outp VSS.t7 nfet_03v3 ad=5p pd=11u as=5p ps=11u w=10u l=0.28u
X36 oqn.t6 VDD.t4 VSS.t54 ppolyf_u r_width=2u r_length=9.14u
X37 tail inp.t14 outn VSS.t79 nfet_03v3 ad=5p pd=11u as=5p ps=11u w=10u l=0.28u
X38 oin.t1 outp x2i_tail VSS.t26 nfet_03v3 ad=5p pd=11u as=5p ps=11u w=10u l=0.28u
X39 oin.t6 VDD.t2 VSS.t38 ppolyf_u r_width=2u r_length=9.14u
X40 x2q_tail outn oqp.t2 VSS.t62 nfet_03v3 ad=5p pd=11u as=5p ps=11u w=10u l=0.28u
X41 tail inn.t15 outp VSS.t9 nfet_03v3 ad=5p pd=11u as=5p ps=11u w=10u l=0.28u
X42 outp inn.t12 tail VSS.t12 nfet_03v3 ad=5p pd=11u as=5p ps=11u w=10u l=0.28u
X43 oip.t1 outn x2i_tail VSS.t55 nfet_03v3 ad=5p pd=11u as=5p ps=11u w=10u l=0.28u
X44 outp inn.t24 tail VSS.t0 nfet_03v3 ad=5p pd=11u as=5p ps=11u w=10u l=0.28u
X45 vcm inp.t0 VSS.t53 ppolyf_u_1k r_width=1u r_length=20u
X46 outn inp.t13 tail VSS.t80 nfet_03v3 ad=5p pd=11u as=5p ps=11u w=10u l=0.28u
X47 vt enb.t0 VDD.t7 VDD.t6 pfet_03v3 ad=2p pd=6u as=2p ps=6u w=2u l=0.28u
X48 tail inp.t2 outn VSS.t91 nfet_03v3 ad=5p pd=11u as=5p ps=11u w=10u l=0.28u
X49 x2i_tail outn oip.t6 VSS.t60 nfet_03v3 ad=5p pd=11u as=5p ps=11u w=10u l=0.28u
X50 vt vcm VSS.t67 ppolyf_u_1k r_width=1u r_length=40u
X51 oqn.t3 outp x2q_tail VSS.t34 nfet_03v3 ad=5p pd=11u as=5p ps=11u w=10u l=0.28u
X52 tail inp.t20 outn VSS.t73 nfet_03v3 ad=5p pd=11u as=5p ps=11u w=10u l=0.28u
X53 outp inn.t10 tail VSS.t14 nfet_03v3 ad=5p pd=11u as=5p ps=11u w=10u l=0.28u
X54 tail inn.t21 outp VSS.t3 nfet_03v3 ad=5p pd=11u as=5p ps=11u w=10u l=0.28u
X55 oqn.t1 outp x2q_tail VSS.t32 nfet_03v3 ad=5p pd=11u as=5p ps=11u w=10u l=0.28u
X56 VSS.t126 nb.t24 tail VSS.t125 nfet_03v3 ad=2.8p pd=10.56u as=5p ps=11u w=10u l=0.5u
X57 tail nb.t21 VSS.t132 VSS.t131 nfet_03v3 ad=5p pd=11u as=2.8p ps=10.56u w=10u l=0.5u
X58 VSS.t122 nb.t26 tail VSS.t121 nfet_03v3 ad=2.8p pd=10.56u as=5p ps=11u w=10u l=0.5u
X59 outp inn.t16 tail VSS.t8 nfet_03v3 ad=5p pd=11u as=5p ps=11u w=10u l=0.28u
X60 x2i_tail outp oin.t0 VSS.t25 nfet_03v3 ad=5p pd=11u as=10p ps=22u w=10u l=0.28u
X61 tail nb.t9 VSS.t156 VSS.t155 nfet_03v3 ad=5p pd=11u as=2.8p ps=10.56u w=10u l=0.5u
X62 tail nb.t23 VSS.t128 VSS.t127 nfet_03v3 ad=5p pd=11u as=2.8p ps=10.56u w=10u l=0.5u
X63 outn inp.t17 tail VSS.t76 nfet_03v3 ad=5p pd=11u as=5p ps=11u w=10u l=0.28u
X64 VSS.t48 vcm VSS.t48 VSS.t47 nfet_03v3 ad=2.7524p pd=10.39u as=0 ps=0 w=9.83u l=10u
X65 tail nb.t11 VSS.t152 VSS.t151 nfet_03v3 ad=5p pd=11u as=2.8p ps=10.56u w=10u l=0.5u
X66 tail inp.t6 outn VSS.t87 nfet_03v3 ad=5p pd=11u as=5p ps=11u w=10u l=0.28u
X67 outp inn.t4 tail VSS.t20 nfet_03v3 ad=5p pd=11u as=5p ps=11u w=10u l=0.28u
X68 tail inn.t7 outp VSS.t17 nfet_03v3 ad=5p pd=11u as=5p ps=11u w=10u l=0.28u
X69 x2i_tail outn oip.t2 VSS.t56 nfet_03v3 ad=5p pd=11u as=5p ps=11u w=10u l=0.28u
X70 VSS.t150 nb.t12 tail VSS.t149 nfet_03v3 ad=2.8p pd=10.56u as=5p ps=11u w=10u l=0.5u
X71 outn inp.t5 tail VSS.t88 nfet_03v3 ad=5p pd=11u as=5p ps=11u w=10u l=0.28u
X72 oin.t3 outp x2i_tail VSS.t28 nfet_03v3 ad=5p pd=11u as=5p ps=11u w=10u l=0.28u
X73 vcm VSS.t41 VSS.t40 ppolyf_u_1k r_width=1u r_length=30u
X74 VDD.t5 outp VSS.t68 ppolyf_u r_width=4u r_length=9.14u
X75 oqn.t5 outp x2q_tail VSS.t36 nfet_03v3 ad=10p pd=22u as=5p ps=11u w=10u l=0.28u
X76 tail inn.t13 outp VSS.t11 nfet_03v3 ad=5p pd=11u as=5p ps=11u w=10u l=0.28u
X77 oip.t3 outn x2i_tail VSS.t57 nfet_03v3 ad=5p pd=11u as=5p ps=11u w=10u l=0.28u
X78 outn inp.t3 tail VSS.t90 nfet_03v3 ad=5p pd=11u as=5p ps=11u w=10u l=0.28u
X79 oqp.t0 VDD.t1 VSS.t37 ppolyf_u r_width=2u r_length=9.14u
X80 outp inn.t22 tail VSS.t2 nfet_03v3 ad=5p pd=11u as=5p ps=11u w=10u l=0.28u
X81 x2i_tail nb.t37 VSS.t100 VSS.t99 nfet_03v3 ad=5p pd=11u as=2.8p ps=10.56u w=10u l=0.5u
X82 outn inp.t23 tail VSS.t70 nfet_03v3 ad=5p pd=11u as=5p ps=11u w=10u l=0.28u
X83 x2i_tail nb.t39 VSS.t96 VSS.t95 nfet_03v3 ad=5p pd=11u as=4.5p ps=20.9u w=10u l=0.5u
X84 tail inn.t1 outp VSS.t23 nfet_03v3 ad=5p pd=11u as=5p ps=11u w=10u l=0.28u
X85 x2q_tail outp oqn.t0 VSS.t31 nfet_03v3 ad=5p pd=11u as=10p ps=22u w=10u l=0.28u
X86 outp inn.t8 tail VSS.t16 nfet_03v3 ad=5p pd=11u as=5p ps=11u w=10u l=0.28u
X87 tail inp.t18 outn VSS.t75 nfet_03v3 ad=5p pd=11u as=5p ps=11u w=10u l=0.28u
X88 tail inn.t19 outp VSS.t5 nfet_03v3 ad=5p pd=11u as=5p ps=11u w=10u l=0.28u
X89 outn inp.t9 tail VSS.t84 nfet_03v3 ad=5p pd=11u as=5p ps=11u w=10u l=0.28u
X90 VSS.t46 vcm VSS.t46 VSS.t45 nfet_03v3 ad=2.7524p pd=10.39u as=0 ps=0 w=9.83u l=10u
X91 tail nb.t17 VSS.t140 VSS.t139 nfet_03v3 ad=5p pd=11u as=2.8p ps=10.56u w=10u l=0.5u
X92 VSS.t130 nb.t22 tail VSS.t129 nfet_03v3 ad=2.8p pd=10.56u as=5p ps=11u w=10u l=0.5u
X93 VSS.t110 nb.t32 x2i_tail VSS.t109 nfet_03v3 ad=4.5p pd=20.9u as=5p ps=11u w=10u l=0.5u
X94 x2i_tail outp oin.t2 VSS.t27 nfet_03v3 ad=5p pd=11u as=5p ps=11u w=10u l=0.28u
X95 VSS.t154 nb.t10 tail VSS.t153 nfet_03v3 ad=2.8p pd=10.56u as=5p ps=11u w=10u l=0.5u
X96 tail nb.t19 VSS.t136 VSS.t135 nfet_03v3 ad=5p pd=11u as=2.8p ps=10.56u w=10u l=0.5u
X97 tail inp.t4 outn VSS.t89 nfet_03v3 ad=5p pd=11u as=5p ps=11u w=10u l=0.28u
X98 oqp.t3 outn x2q_tail VSS.t63 nfet_03v3 ad=5p pd=11u as=5p ps=11u w=10u l=0.28u
X99 VDD.t3 outn VSS.t42 ppolyf_u r_width=4u r_length=9.14u
X100 tail inn.t5 outp VSS.t19 nfet_03v3 ad=5p pd=11u as=5p ps=11u w=10u l=0.28u
X101 VSS.t44 vcm VSS.t44 VSS.t43 nfet_03v3 ad=4.4235p pd=20.56u as=0 ps=0 w=9.83u l=10u
X102 tail inp.t24 outn VSS.t69 nfet_03v3 ad=5p pd=11u as=10p ps=22u w=10u l=0.28u
X103 x2q_tail outp oqn.t4 VSS.t35 nfet_03v3 ad=5p pd=11u as=5p ps=11u w=10u l=0.28u
X104 tail inp.t12 outn VSS.t81 nfet_03v3 ad=5p pd=11u as=5p ps=11u w=10u l=0.28u
X105 x2q_tail nb.t7 VSS.t94 VSS.t93 nfet_03v3 ad=5p pd=11u as=10p ps=22u w=10u l=0.5u
X106 oqp.t1 outn x2q_tail VSS.t61 nfet_03v3 ad=5p pd=11u as=5p ps=11u w=10u l=0.28u
X107 VSS.t52 vcm VSS.t52 VSS.t51 nfet_03v3 ad=4.915p pd=10.83u as=0 ps=0 w=9.83u l=10u
X108 x2q_tail outp oqn.t2 VSS.t33 nfet_03v3 ad=5p pd=11u as=5p ps=11u w=10u l=0.28u
X109 oin.t5 outp x2i_tail VSS.t30 nfet_03v3 ad=10p pd=22u as=5p ps=11u w=10u l=0.28u
X110 tail inn.t23 outp VSS.t1 nfet_03v3 ad=5p pd=11u as=5p ps=11u w=10u l=0.28u
X111 VSS.t164 nb.t4 x2q_tail VSS.t163 nfet_03v3 ad=5p pd=11u as=5p ps=11u w=10u l=0.5u
X112 tail nb.t29 VSS.t116 VSS.t115 nfet_03v3 ad=5p pd=11u as=2.8p ps=10.56u w=10u l=0.5u
X113 outn inp.t1 tail VSS.t92 nfet_03v3 ad=10p pd=22u as=5p ps=11u w=10u l=0.28u
X114 oip.t5 outn x2i_tail VSS.t59 nfet_03v3 ad=5p pd=11u as=5p ps=11u w=10u l=0.28u
X115 outp inn.t20 tail VSS.t4 nfet_03v3 ad=5p pd=11u as=5p ps=11u w=10u l=0.28u
X116 VSS.t98 nb.t38 x2i_tail VSS.t97 nfet_03v3 ad=2.8p pd=10.56u as=5p ps=11u w=10u l=0.5u
X117 outp inn.t2 tail VSS.t22 nfet_03v3 ad=5p pd=11u as=5p ps=11u w=10u l=0.28u
X118 tail nb.t31 VSS.t112 VSS.t111 nfet_03v3 ad=5p pd=11u as=4.5p ps=20.9u w=10u l=0.5u
X119 outn inp.t21 tail VSS.t72 nfet_03v3 ad=5p pd=11u as=5p ps=11u w=10u l=0.28u
X120 x2i_tail nb.t35 VSS.t104 VSS.t103 nfet_03v3 ad=5p pd=11u as=2.8p ps=10.56u w=10u l=0.5u
X121 tail inp.t10 outn VSS.t83 nfet_03v3 ad=5p pd=11u as=5p ps=11u w=10u l=0.28u
X122 VSS.t160 nb.t6 x2q_tail VSS.t159 nfet_03v3 ad=5p pd=11u as=5p ps=11u w=10u l=0.5u
X123 tail nb.t13 VSS.t148 VSS.t147 nfet_03v3 ad=5p pd=11u as=2.8p ps=10.56u w=10u l=0.5u
X124 VSS.t50 vcm VSS.t50 VSS.t49 nfet_03v3 ad=9.83p pd=21.66u as=0 ps=0 w=9.83u l=10u
X125 x2q_tail nb.t1 VSS.t170 VSS.t169 nfet_03v3 ad=5p pd=11u as=5p ps=11u w=10u l=0.5u
X126 tail inn.t11 outp VSS.t13 nfet_03v3 ad=5p pd=11u as=5p ps=11u w=10u l=0.28u
X127 tail nb.t15 VSS.t144 VSS.t143 nfet_03v3 ad=5p pd=11u as=2.8p ps=10.56u w=10u l=0.5u
R0 oqp.n5 oqp.t0 9.24997
R1 oqp.n2 oqp.n0 8.87418
R2 oqp.n2 oqp.n1 7.66155
R3 oqp.n4 oqp.n3 7.66155
R4 oqp oqp.n5 7.36155
R5 oqp.n5 oqp.n4 4.72313
R6 oqp.n4 oqp.n2 1.21313
R7 oqp.n0 oqp.t2 0.3155
R8 oqp.n0 oqp.t1 0.3155
R9 oqp.n1 oqp.t4 0.3155
R10 oqp.n1 oqp.t3 0.3155
R11 oqp.n3 oqp.t6 0.3155
R12 oqp.n3 oqp.t5 0.3155
R13 oqn oqn.n5 10.3955
R14 oqn.n0 oqn.t6 10.0031
R15 oqn.n0 oqn.t0 7.17129
R16 oqn.n5 oqn.t5 7.17129
R17 oqn.n2 oqn.n1 6.85629
R18 oqn.n4 oqn.n3 6.85629
R19 oqn.n5 oqn.n4 1.21313
R20 oqn.n4 oqn.n2 1.21313
R21 oqn.n2 oqn.n0 1.21313
R22 oqn.n1 oqn.t2 0.3155
R23 oqn.n1 oqn.t1 0.3155
R24 oqn.n3 oqn.t4 0.3155
R25 oqn.n3 oqn.t3 0.3155
R26 enb enb.t0 59.5566
R27 inn.n0 inn.t1 154.482
R28 inn.n22 inn.t24 154.179
R29 inn.n21 inn.t23 154.179
R30 inn.n20 inn.t22 154.179
R31 inn.n19 inn.t21 154.179
R32 inn.n18 inn.t20 154.179
R33 inn.n17 inn.t19 154.179
R34 inn.n16 inn.t18 154.179
R35 inn.n15 inn.t17 154.179
R36 inn.n14 inn.t16 154.179
R37 inn.n13 inn.t15 154.179
R38 inn.n12 inn.t14 154.179
R39 inn.n11 inn.t13 154.179
R40 inn.n10 inn.t12 154.179
R41 inn.n9 inn.t11 154.179
R42 inn.n8 inn.t10 154.179
R43 inn.n7 inn.t9 154.179
R44 inn.n6 inn.t8 154.179
R45 inn.n5 inn.t7 154.179
R46 inn.n4 inn.t6 154.179
R47 inn.n3 inn.t5 154.179
R48 inn.n2 inn.t4 154.179
R49 inn.n1 inn.t3 154.179
R50 inn.n0 inn.t2 154.179
R51 inn.n23 inn.t0 11.9438
R52 inn.n23 inn.n22 2.39261
R53 inn inn.n23 2.06103
R54 inn.n1 inn.n0 0.909974
R55 inn.n3 inn.n2 0.909974
R56 inn.n5 inn.n4 0.909974
R57 inn.n7 inn.n6 0.909974
R58 inn.n9 inn.n8 0.909974
R59 inn.n11 inn.n10 0.909974
R60 inn.n13 inn.n12 0.909974
R61 inn.n17 inn.n16 0.909974
R62 inn.n19 inn.n18 0.909974
R63 inn.n21 inn.n20 0.909974
R64 inn.n15 inn 0.677868
R65 inn.n2 inn.n1 0.303658
R66 inn.n4 inn.n3 0.303658
R67 inn.n6 inn.n5 0.303658
R68 inn.n8 inn.n7 0.303658
R69 inn.n10 inn.n9 0.303658
R70 inn.n12 inn.n11 0.303658
R71 inn.n14 inn.n13 0.303658
R72 inn.n16 inn.n15 0.303658
R73 inn.n18 inn.n17 0.303658
R74 inn.n20 inn.n19 0.303658
R75 inn.n22 inn.n21 0.303658
R76 inn inn.n14 0.232605
R77 inp.n0 inp.t1 154.928
R78 inp.n22 inp.t24 154.018
R79 inp.n21 inp.t23 154.018
R80 inp.n20 inp.t22 154.018
R81 inp.n19 inp.t21 154.018
R82 inp.n18 inp.t20 154.018
R83 inp.n17 inp.t19 154.018
R84 inp.n16 inp.t18 154.018
R85 inp.n15 inp.t17 154.018
R86 inp.n14 inp.t16 154.018
R87 inp.n13 inp.t15 154.018
R88 inp.n12 inp.t14 154.018
R89 inp.n11 inp.t13 154.018
R90 inp.n10 inp.t12 154.018
R91 inp.n9 inp.t11 154.018
R92 inp.n8 inp.t10 154.018
R93 inp.n7 inp.t9 154.018
R94 inp.n6 inp.t8 154.018
R95 inp.n5 inp.t7 154.018
R96 inp.n4 inp.t6 154.018
R97 inp.n3 inp.t5 154.018
R98 inp.n2 inp.t4 154.018
R99 inp.n1 inp.t3 154.018
R100 inp.n0 inp.t2 154.018
R101 inp.n23 inp.t0 11.7828
R102 inp.n23 inp.n22 3.84208
R103 inp.n2 inp.n1 0.909974
R104 inp.n4 inp.n3 0.909974
R105 inp.n6 inp.n5 0.909974
R106 inp.n8 inp.n7 0.909974
R107 inp.n10 inp.n9 0.909974
R108 inp.n12 inp.n11 0.909974
R109 inp.n16 inp.n15 0.909974
R110 inp.n18 inp.n17 0.909974
R111 inp.n20 inp.n19 0.909974
R112 inp.n22 inp.n21 0.909974
R113 inp inp.n13 0.687342
R114 inp inp.n23 0.308395
R115 inp.n1 inp.n0 0.303658
R116 inp.n3 inp.n2 0.303658
R117 inp.n5 inp.n4 0.303658
R118 inp.n7 inp.n6 0.303658
R119 inp.n9 inp.n8 0.303658
R120 inp.n11 inp.n10 0.303658
R121 inp.n13 inp.n12 0.303658
R122 inp.n15 inp.n14 0.303658
R123 inp.n17 inp.n16 0.303658
R124 inp.n19 inp.n18 0.303658
R125 inp.n21 inp.n20 0.303658
R126 inp.n14 inp 0.223132
R127 oip.n5 oip.t0 8.71589
R128 oip.n2 oip.n0 8.34011
R129 oip oip.n5 7.93471
R130 oip.n2 oip.n1 7.12747
R131 oip.n4 oip.n3 7.12747
R132 oip.n5 oip.n4 4.14997
R133 oip.n4 oip.n2 1.21313
R134 oip.n0 oip.t2 0.3155
R135 oip.n0 oip.t1 0.3155
R136 oip.n1 oip.t4 0.3155
R137 oip.n1 oip.t3 0.3155
R138 oip.n3 oip.t6 0.3155
R139 oip.n3 oip.t5 0.3155
R140 nb.n31 nb.t7 93.4411
R141 nb.n7 nb.t8 93.4067
R142 nb.n31 nb.t6 93.0858
R143 nb.n32 nb.t5 93.0858
R144 nb.n33 nb.t4 93.0858
R145 nb.n34 nb.t3 93.0858
R146 nb.n35 nb.t2 93.0858
R147 nb.n36 nb.t1 93.0858
R148 nb.n37 nb.t0 93.0858
R149 nb.n29 nb.t31 93.0514
R150 nb.n28 nb.t30 93.0514
R151 nb.n27 nb.t29 93.0514
R152 nb.n26 nb.t28 93.0514
R153 nb.n25 nb.t27 93.0514
R154 nb.n24 nb.t26 93.0514
R155 nb.n23 nb.t25 93.0514
R156 nb.n22 nb.t24 93.0514
R157 nb.n21 nb.t23 93.0514
R158 nb.n20 nb.t22 93.0514
R159 nb.n19 nb.t21 93.0514
R160 nb.n18 nb.t20 93.0514
R161 nb.n17 nb.t19 93.0514
R162 nb.n16 nb.t18 93.0514
R163 nb.n15 nb.t17 93.0514
R164 nb.n14 nb.t16 93.0514
R165 nb.n13 nb.t15 93.0514
R166 nb.n12 nb.t14 93.0514
R167 nb.n11 nb.t13 93.0514
R168 nb.n10 nb.t12 93.0514
R169 nb.n9 nb.t11 93.0514
R170 nb.n8 nb.t10 93.0514
R171 nb.n7 nb.t9 93.0514
R172 nb.n0 nb.t39 92.907
R173 nb.n0 nb.t38 92.5517
R174 nb.n1 nb.t37 92.5517
R175 nb.n2 nb.t36 92.5517
R176 nb.n3 nb.t35 92.5517
R177 nb.n4 nb.t34 92.5517
R178 nb.n5 nb.t33 92.5517
R179 nb.n6 nb.t32 92.5517
R180 nb.n30 nb 16.9134
R181 nb.n30 nb.n29 7.41839
R182 nb.n38 nb.n37 7.39234
R183 nb nb.n38 6.37747
R184 nb nb.n6 2.83076
R185 nb.n38 nb 2.74432
R186 nb nb.n30 1.34458
R187 nb.n6 nb.n5 0.355763
R188 nb.n4 nb.n3 0.355763
R189 nb.n2 nb.n1 0.355763
R190 nb.n37 nb.n36 0.355763
R191 nb.n36 nb.n35 0.355763
R192 nb.n35 nb.n34 0.355763
R193 nb.n34 nb.n33 0.355763
R194 nb.n33 nb.n32 0.355763
R195 nb.n32 nb.n31 0.355763
R196 nb.n9 nb.n8 0.355763
R197 nb.n11 nb.n10 0.355763
R198 nb.n13 nb.n12 0.355763
R199 nb.n15 nb.n14 0.355763
R200 nb.n17 nb.n16 0.355763
R201 nb.n19 nb.n18 0.355763
R202 nb.n21 nb.n20 0.355763
R203 nb.n25 nb.n24 0.355763
R204 nb.n27 nb.n26 0.355763
R205 nb.n29 nb.n28 0.355763
R206 nb.n5 nb.n4 0.251553
R207 nb.n3 nb.n2 0.251553
R208 nb.n1 nb.n0 0.251553
R209 nb.n8 nb.n7 0.251553
R210 nb.n10 nb.n9 0.251553
R211 nb.n12 nb.n11 0.251553
R212 nb.n14 nb.n13 0.251553
R213 nb.n16 nb.n15 0.251553
R214 nb.n18 nb.n17 0.251553
R215 nb.n20 nb.n19 0.251553
R216 nb.n22 nb.n21 0.251553
R217 nb.n24 nb.n23 0.251553
R218 nb.n26 nb.n25 0.251553
R219 nb.n28 nb.n27 0.251553
R220 nb.n23 nb 0.234974
R221 nb nb.n22 0.121289
R222 oin oin.n5 10.3955
R223 oin.n0 oin.t6 9.46905
R224 oin.n0 oin.t0 6.63721
R225 oin.n5 oin.t5 6.63721
R226 oin.n2 oin.n1 6.32221
R227 oin.n4 oin.n3 6.32221
R228 oin.n5 oin.n4 1.21313
R229 oin.n4 oin.n2 1.21313
R230 oin.n2 oin.n0 1.21313
R231 oin.n1 oin.t2 0.3155
R232 oin.n1 oin.t1 0.3155
R233 oin.n3 oin.t4 0.3155
R234 oin.n3 oin.t3 0.3155
R235 VDD.n158 VDD.t1 17.7502
R236 VDD.n481 VDD.t0 16.643
R237 VDD.n304 VDD.n303 10.8941
R238 VDD.n159 VDD.n158 10.8135
R239 VDD.n482 VDD.n481 10.5767
R240 VDD.n303 VDD.t5 9.24129
R241 VDD.n158 VDD.t4 8.77392
R242 VDD.n481 VDD.t2 8.23984
R243 VDD.n303 VDD.t3 6.80181
R244 VDD.n484 VDD.n483 4.98179
R245 VDD.n210 VDD.t7 3.42945
R246 VDD.n317 VDD.n316 1.94435
R247 VDD.n231 VDD.n122 1.5755
R248 VDD.n206 VDD.n205 1.5755
R249 VDD.n301 VDD.n300 1.5755
R250 VDD.n238 VDD.n119 1.5755
R251 VDD.n310 VDD.n87 1.5755
R252 VDD.n479 VDD.n478 1.5755
R253 VDD.n174 VDD.n173 1.5755
R254 VDD.n165 VDD.n157 1.5755
R255 VDD.n198 VDD.n139 1.5755
R256 VDD.n181 VDD.n149 1.5755
R257 VDD.n316 VDD.n315 1.51013
R258 VDD.n317 VDD.n82 1.50681
R259 VDD.n478 VDD.n477 1.5005
R260 VDD.n5 VDD.n4 1.5005
R261 VDD.n471 VDD.n470 1.5005
R262 VDD.n469 VDD.n468 1.5005
R263 VDD.n9 VDD.n8 1.5005
R264 VDD.n463 VDD.n462 1.5005
R265 VDD.n461 VDD.n460 1.5005
R266 VDD.n13 VDD.n12 1.5005
R267 VDD.n455 VDD.n454 1.5005
R268 VDD.n453 VDD.n452 1.5005
R269 VDD.n17 VDD.n16 1.5005
R270 VDD.n447 VDD.n446 1.5005
R271 VDD.n445 VDD.n444 1.5005
R272 VDD.n21 VDD.n20 1.5005
R273 VDD.n439 VDD.n438 1.5005
R274 VDD.n437 VDD.n436 1.5005
R275 VDD.n25 VDD.n24 1.5005
R276 VDD.n431 VDD.n430 1.5005
R277 VDD.n429 VDD.n428 1.5005
R278 VDD.n29 VDD.n28 1.5005
R279 VDD.n423 VDD.n422 1.5005
R280 VDD.n421 VDD.n420 1.5005
R281 VDD.n33 VDD.n32 1.5005
R282 VDD.n415 VDD.n414 1.5005
R283 VDD.n413 VDD.n412 1.5005
R284 VDD.n37 VDD.n36 1.5005
R285 VDD.n407 VDD.n406 1.5005
R286 VDD.n405 VDD.n404 1.5005
R287 VDD.n41 VDD.n40 1.5005
R288 VDD.n399 VDD.n398 1.5005
R289 VDD.n397 VDD.n396 1.5005
R290 VDD.n45 VDD.n44 1.5005
R291 VDD.n391 VDD.n390 1.5005
R292 VDD.n389 VDD.n388 1.5005
R293 VDD.n49 VDD.n48 1.5005
R294 VDD.n383 VDD.n382 1.5005
R295 VDD.n381 VDD.n380 1.5005
R296 VDD.n53 VDD.n52 1.5005
R297 VDD.n375 VDD.n374 1.5005
R298 VDD.n373 VDD.n372 1.5005
R299 VDD.n57 VDD.n56 1.5005
R300 VDD.n367 VDD.n366 1.5005
R301 VDD.n365 VDD.n364 1.5005
R302 VDD.n61 VDD.n60 1.5005
R303 VDD.n359 VDD.n358 1.5005
R304 VDD.n357 VDD.n356 1.5005
R305 VDD.n65 VDD.n64 1.5005
R306 VDD.n351 VDD.n350 1.5005
R307 VDD.n349 VDD.n348 1.5005
R308 VDD.n69 VDD.n68 1.5005
R309 VDD.n343 VDD.n342 1.5005
R310 VDD.n341 VDD.n340 1.5005
R311 VDD.n73 VDD.n72 1.5005
R312 VDD.n335 VDD.n334 1.5005
R313 VDD.n333 VDD.n332 1.5005
R314 VDD.n77 VDD.n76 1.5005
R315 VDD.n327 VDD.n326 1.5005
R316 VDD.n325 VDD.n324 1.5005
R317 VDD.n81 VDD.n80 1.5005
R318 VDD.n319 VDD.n318 1.5005
R319 VDD.n480 VDD.n2 1.5005
R320 VDD.n474 VDD.n3 1.5005
R321 VDD.n476 VDD.n475 1.5005
R322 VDD.n473 VDD.n472 1.5005
R323 VDD.n7 VDD.n6 1.5005
R324 VDD.n467 VDD.n466 1.5005
R325 VDD.n465 VDD.n464 1.5005
R326 VDD.n11 VDD.n10 1.5005
R327 VDD.n459 VDD.n458 1.5005
R328 VDD.n457 VDD.n456 1.5005
R329 VDD.n15 VDD.n14 1.5005
R330 VDD.n451 VDD.n450 1.5005
R331 VDD.n449 VDD.n448 1.5005
R332 VDD.n19 VDD.n18 1.5005
R333 VDD.n443 VDD.n442 1.5005
R334 VDD.n441 VDD.n440 1.5005
R335 VDD.n23 VDD.n22 1.5005
R336 VDD.n435 VDD.n434 1.5005
R337 VDD.n433 VDD.n432 1.5005
R338 VDD.n27 VDD.n26 1.5005
R339 VDD.n427 VDD.n426 1.5005
R340 VDD.n425 VDD.n424 1.5005
R341 VDD.n31 VDD.n30 1.5005
R342 VDD.n419 VDD.n418 1.5005
R343 VDD.n417 VDD.n416 1.5005
R344 VDD.n35 VDD.n34 1.5005
R345 VDD.n411 VDD.n410 1.5005
R346 VDD.n409 VDD.n408 1.5005
R347 VDD.n39 VDD.n38 1.5005
R348 VDD.n403 VDD.n402 1.5005
R349 VDD.n401 VDD.n400 1.5005
R350 VDD.n43 VDD.n42 1.5005
R351 VDD.n395 VDD.n394 1.5005
R352 VDD.n393 VDD.n392 1.5005
R353 VDD.n47 VDD.n46 1.5005
R354 VDD.n387 VDD.n386 1.5005
R355 VDD.n385 VDD.n384 1.5005
R356 VDD.n51 VDD.n50 1.5005
R357 VDD.n379 VDD.n378 1.5005
R358 VDD.n377 VDD.n376 1.5005
R359 VDD.n55 VDD.n54 1.5005
R360 VDD.n371 VDD.n370 1.5005
R361 VDD.n369 VDD.n368 1.5005
R362 VDD.n59 VDD.n58 1.5005
R363 VDD.n363 VDD.n362 1.5005
R364 VDD.n361 VDD.n360 1.5005
R365 VDD.n63 VDD.n62 1.5005
R366 VDD.n355 VDD.n354 1.5005
R367 VDD.n353 VDD.n352 1.5005
R368 VDD.n67 VDD.n66 1.5005
R369 VDD.n347 VDD.n346 1.5005
R370 VDD.n345 VDD.n344 1.5005
R371 VDD.n71 VDD.n70 1.5005
R372 VDD.n339 VDD.n338 1.5005
R373 VDD.n337 VDD.n336 1.5005
R374 VDD.n75 VDD.n74 1.5005
R375 VDD.n331 VDD.n330 1.5005
R376 VDD.n329 VDD.n328 1.5005
R377 VDD.n79 VDD.n78 1.5005
R378 VDD.n323 VDD.n322 1.5005
R379 VDD.n321 VDD.n320 1.5005
R380 VDD.n1 VDD.n0 1.5005
R381 VDD.n161 VDD.n160 1.5005
R382 VDD.n163 VDD.n162 1.5005
R383 VDD.n156 VDD.n155 1.5005
R384 VDD.n169 VDD.n168 1.5005
R385 VDD.n171 VDD.n170 1.5005
R386 VDD.n154 VDD.n151 1.5005
R387 VDD.n175 VDD.n150 1.5005
R388 VDD.n177 VDD.n176 1.5005
R389 VDD.n179 VDD.n178 1.5005
R390 VDD.n148 VDD.n147 1.5005
R391 VDD.n185 VDD.n184 1.5005
R392 VDD.n187 VDD.n186 1.5005
R393 VDD.n144 VDD.n143 1.5005
R394 VDD.n193 VDD.n192 1.5005
R395 VDD.n195 VDD.n194 1.5005
R396 VDD.n140 VDD.n138 1.5005
R397 VDD.n201 VDD.n200 1.5005
R398 VDD.n199 VDD.n198 1.5005
R399 VDD.n197 VDD.n196 1.5005
R400 VDD.n142 VDD.n141 1.5005
R401 VDD.n191 VDD.n190 1.5005
R402 VDD.n189 VDD.n188 1.5005
R403 VDD.n146 VDD.n145 1.5005
R404 VDD.n183 VDD.n182 1.5005
R405 VDD.n181 VDD.n180 1.5005
R406 VDD.n173 VDD.n172 1.5005
R407 VDD.n153 VDD.n152 1.5005
R408 VDD.n167 VDD.n166 1.5005
R409 VDD.n165 VDD.n164 1.5005
R410 VDD.n84 VDD.n83 1.5005
R411 VDD.n312 VDD.n311 1.5005
R412 VDD.n310 VDD.n309 1.5005
R413 VDD.n300 VDD.n299 1.5005
R414 VDD.n91 VDD.n90 1.5005
R415 VDD.n294 VDD.n293 1.5005
R416 VDD.n292 VDD.n291 1.5005
R417 VDD.n96 VDD.n95 1.5005
R418 VDD.n286 VDD.n285 1.5005
R419 VDD.n284 VDD.n283 1.5005
R420 VDD.n100 VDD.n99 1.5005
R421 VDD.n278 VDD.n277 1.5005
R422 VDD.n276 VDD.n275 1.5005
R423 VDD.n104 VDD.n103 1.5005
R424 VDD.n270 VDD.n269 1.5005
R425 VDD.n268 VDD.n267 1.5005
R426 VDD.n108 VDD.n107 1.5005
R427 VDD.n262 VDD.n261 1.5005
R428 VDD.n260 VDD.n259 1.5005
R429 VDD.n112 VDD.n111 1.5005
R430 VDD.n254 VDD.n253 1.5005
R431 VDD.n252 VDD.n251 1.5005
R432 VDD.n116 VDD.n115 1.5005
R433 VDD.n246 VDD.n245 1.5005
R434 VDD.n244 VDD.n243 1.5005
R435 VDD.n120 VDD.n119 1.5005
R436 VDD.n232 VDD.n231 1.5005
R437 VDD.n230 VDD.n229 1.5005
R438 VDD.n126 VDD.n125 1.5005
R439 VDD.n224 VDD.n223 1.5005
R440 VDD.n222 VDD.n221 1.5005
R441 VDD.n130 VDD.n129 1.5005
R442 VDD.n216 VDD.n215 1.5005
R443 VDD.n214 VDD.n213 1.5005
R444 VDD.n134 VDD.n133 1.5005
R445 VDD.n207 VDD.n206 1.5005
R446 VDD.n202 VDD.n137 1.5005
R447 VDD.n204 VDD.n203 1.5005
R448 VDD.n136 VDD.n135 1.5005
R449 VDD.n209 VDD.n208 1.5005
R450 VDD.n212 VDD.n211 1.5005
R451 VDD.n132 VDD.n131 1.5005
R452 VDD.n218 VDD.n217 1.5005
R453 VDD.n220 VDD.n219 1.5005
R454 VDD.n128 VDD.n127 1.5005
R455 VDD.n226 VDD.n225 1.5005
R456 VDD.n228 VDD.n227 1.5005
R457 VDD.n124 VDD.n123 1.5005
R458 VDD.n234 VDD.n233 1.5005
R459 VDD.n236 VDD.n235 1.5005
R460 VDD.n237 VDD.n121 1.5005
R461 VDD.n240 VDD.n239 1.5005
R462 VDD.n242 VDD.n241 1.5005
R463 VDD.n118 VDD.n117 1.5005
R464 VDD.n248 VDD.n247 1.5005
R465 VDD.n250 VDD.n249 1.5005
R466 VDD.n114 VDD.n113 1.5005
R467 VDD.n256 VDD.n255 1.5005
R468 VDD.n258 VDD.n257 1.5005
R469 VDD.n110 VDD.n109 1.5005
R470 VDD.n264 VDD.n263 1.5005
R471 VDD.n266 VDD.n265 1.5005
R472 VDD.n106 VDD.n105 1.5005
R473 VDD.n272 VDD.n271 1.5005
R474 VDD.n274 VDD.n273 1.5005
R475 VDD.n102 VDD.n101 1.5005
R476 VDD.n280 VDD.n279 1.5005
R477 VDD.n282 VDD.n281 1.5005
R478 VDD.n98 VDD.n97 1.5005
R479 VDD.n288 VDD.n287 1.5005
R480 VDD.n290 VDD.n289 1.5005
R481 VDD.n94 VDD.n93 1.5005
R482 VDD.n296 VDD.n295 1.5005
R483 VDD.n298 VDD.n297 1.5005
R484 VDD.n92 VDD.n89 1.5005
R485 VDD.n302 VDD.n88 1.5005
R486 VDD.n306 VDD.n305 1.5005
R487 VDD.n308 VDD.n307 1.5005
R488 VDD.n86 VDD.n85 1.5005
R489 VDD.n314 VDD.n313 1.5005
R490 VDD.n485 VDD.n0 0.835821
R491 VDD.n321 VDD.n82 0.643161
R492 VDD.n315 VDD.n314 0.637621
R493 VDD.n483 VDD.n2 0.624534
R494 VDD.n231 VDD.n230 0.0755
R495 VDD.n230 VDD.n125 0.0755
R496 VDD.n223 VDD.n125 0.0755
R497 VDD.n223 VDD.n222 0.0755
R498 VDD.n222 VDD.n129 0.0755
R499 VDD.n215 VDD.n129 0.0755
R500 VDD.n215 VDD.n214 0.0755
R501 VDD.n214 VDD.n133 0.0755
R502 VDD.n206 VDD.n133 0.0755
R503 VDD.n300 VDD.n90 0.0755
R504 VDD.n293 VDD.n90 0.0755
R505 VDD.n293 VDD.n292 0.0755
R506 VDD.n292 VDD.n95 0.0755
R507 VDD.n285 VDD.n95 0.0755
R508 VDD.n285 VDD.n284 0.0755
R509 VDD.n284 VDD.n99 0.0755
R510 VDD.n277 VDD.n99 0.0755
R511 VDD.n277 VDD.n276 0.0755
R512 VDD.n276 VDD.n103 0.0755
R513 VDD.n269 VDD.n103 0.0755
R514 VDD.n269 VDD.n268 0.0755
R515 VDD.n268 VDD.n107 0.0755
R516 VDD.n261 VDD.n107 0.0755
R517 VDD.n261 VDD.n260 0.0755
R518 VDD.n260 VDD.n111 0.0755
R519 VDD.n253 VDD.n111 0.0755
R520 VDD.n253 VDD.n252 0.0755
R521 VDD.n252 VDD.n115 0.0755
R522 VDD.n245 VDD.n115 0.0755
R523 VDD.n245 VDD.n244 0.0755
R524 VDD.n244 VDD.n119 0.0755
R525 VDD.n322 VDD.n321 0.0755
R526 VDD.n322 VDD.n78 0.0755
R527 VDD.n329 VDD.n78 0.0755
R528 VDD.n330 VDD.n329 0.0755
R529 VDD.n330 VDD.n74 0.0755
R530 VDD.n337 VDD.n74 0.0755
R531 VDD.n338 VDD.n337 0.0755
R532 VDD.n338 VDD.n70 0.0755
R533 VDD.n345 VDD.n70 0.0755
R534 VDD.n346 VDD.n345 0.0755
R535 VDD.n346 VDD.n66 0.0755
R536 VDD.n353 VDD.n66 0.0755
R537 VDD.n354 VDD.n353 0.0755
R538 VDD.n354 VDD.n62 0.0755
R539 VDD.n361 VDD.n62 0.0755
R540 VDD.n362 VDD.n361 0.0755
R541 VDD.n362 VDD.n58 0.0755
R542 VDD.n369 VDD.n58 0.0755
R543 VDD.n370 VDD.n369 0.0755
R544 VDD.n370 VDD.n54 0.0755
R545 VDD.n377 VDD.n54 0.0755
R546 VDD.n378 VDD.n377 0.0755
R547 VDD.n378 VDD.n50 0.0755
R548 VDD.n385 VDD.n50 0.0755
R549 VDD.n386 VDD.n385 0.0755
R550 VDD.n386 VDD.n46 0.0755
R551 VDD.n393 VDD.n46 0.0755
R552 VDD.n394 VDD.n393 0.0755
R553 VDD.n394 VDD.n42 0.0755
R554 VDD.n401 VDD.n42 0.0755
R555 VDD.n402 VDD.n401 0.0755
R556 VDD.n402 VDD.n38 0.0755
R557 VDD.n409 VDD.n38 0.0755
R558 VDD.n410 VDD.n409 0.0755
R559 VDD.n410 VDD.n34 0.0755
R560 VDD.n417 VDD.n34 0.0755
R561 VDD.n418 VDD.n417 0.0755
R562 VDD.n418 VDD.n30 0.0755
R563 VDD.n425 VDD.n30 0.0755
R564 VDD.n426 VDD.n425 0.0755
R565 VDD.n426 VDD.n26 0.0755
R566 VDD.n433 VDD.n26 0.0755
R567 VDD.n434 VDD.n433 0.0755
R568 VDD.n434 VDD.n22 0.0755
R569 VDD.n441 VDD.n22 0.0755
R570 VDD.n442 VDD.n441 0.0755
R571 VDD.n442 VDD.n18 0.0755
R572 VDD.n449 VDD.n18 0.0755
R573 VDD.n450 VDD.n449 0.0755
R574 VDD.n450 VDD.n14 0.0755
R575 VDD.n457 VDD.n14 0.0755
R576 VDD.n458 VDD.n457 0.0755
R577 VDD.n458 VDD.n10 0.0755
R578 VDD.n465 VDD.n10 0.0755
R579 VDD.n466 VDD.n465 0.0755
R580 VDD.n466 VDD.n6 0.0755
R581 VDD.n473 VDD.n6 0.0755
R582 VDD.n475 VDD.n473 0.0755
R583 VDD.n475 VDD.n474 0.0755
R584 VDD.n474 VDD.n2 0.0755
R585 VDD.n316 VDD.n83 0.0755
R586 VDD.n311 VDD.n83 0.0755
R587 VDD.n311 VDD.n310 0.0755
R588 VDD.n318 VDD.n317 0.0755
R589 VDD.n318 VDD.n80 0.0755
R590 VDD.n325 VDD.n80 0.0755
R591 VDD.n326 VDD.n325 0.0755
R592 VDD.n326 VDD.n76 0.0755
R593 VDD.n333 VDD.n76 0.0755
R594 VDD.n334 VDD.n333 0.0755
R595 VDD.n334 VDD.n72 0.0755
R596 VDD.n341 VDD.n72 0.0755
R597 VDD.n342 VDD.n341 0.0755
R598 VDD.n342 VDD.n68 0.0755
R599 VDD.n349 VDD.n68 0.0755
R600 VDD.n350 VDD.n349 0.0755
R601 VDD.n350 VDD.n64 0.0755
R602 VDD.n357 VDD.n64 0.0755
R603 VDD.n358 VDD.n357 0.0755
R604 VDD.n358 VDD.n60 0.0755
R605 VDD.n365 VDD.n60 0.0755
R606 VDD.n366 VDD.n365 0.0755
R607 VDD.n366 VDD.n56 0.0755
R608 VDD.n373 VDD.n56 0.0755
R609 VDD.n374 VDD.n373 0.0755
R610 VDD.n374 VDD.n52 0.0755
R611 VDD.n381 VDD.n52 0.0755
R612 VDD.n382 VDD.n381 0.0755
R613 VDD.n382 VDD.n48 0.0755
R614 VDD.n389 VDD.n48 0.0755
R615 VDD.n390 VDD.n389 0.0755
R616 VDD.n390 VDD.n44 0.0755
R617 VDD.n397 VDD.n44 0.0755
R618 VDD.n398 VDD.n397 0.0755
R619 VDD.n398 VDD.n40 0.0755
R620 VDD.n405 VDD.n40 0.0755
R621 VDD.n406 VDD.n405 0.0755
R622 VDD.n406 VDD.n36 0.0755
R623 VDD.n413 VDD.n36 0.0755
R624 VDD.n414 VDD.n413 0.0755
R625 VDD.n414 VDD.n32 0.0755
R626 VDD.n421 VDD.n32 0.0755
R627 VDD.n422 VDD.n421 0.0755
R628 VDD.n422 VDD.n28 0.0755
R629 VDD.n429 VDD.n28 0.0755
R630 VDD.n430 VDD.n429 0.0755
R631 VDD.n430 VDD.n24 0.0755
R632 VDD.n437 VDD.n24 0.0755
R633 VDD.n438 VDD.n437 0.0755
R634 VDD.n438 VDD.n20 0.0755
R635 VDD.n445 VDD.n20 0.0755
R636 VDD.n446 VDD.n445 0.0755
R637 VDD.n446 VDD.n16 0.0755
R638 VDD.n453 VDD.n16 0.0755
R639 VDD.n454 VDD.n453 0.0755
R640 VDD.n454 VDD.n12 0.0755
R641 VDD.n461 VDD.n12 0.0755
R642 VDD.n462 VDD.n461 0.0755
R643 VDD.n462 VDD.n8 0.0755
R644 VDD.n469 VDD.n8 0.0755
R645 VDD.n470 VDD.n469 0.0755
R646 VDD.n470 VDD.n4 0.0755
R647 VDD.n478 VDD.n4 0.0755
R648 VDD.n173 VDD.n152 0.0755
R649 VDD.n166 VDD.n152 0.0755
R650 VDD.n166 VDD.n165 0.0755
R651 VDD.n198 VDD.n197 0.0755
R652 VDD.n197 VDD.n141 0.0755
R653 VDD.n190 VDD.n141 0.0755
R654 VDD.n190 VDD.n189 0.0755
R655 VDD.n189 VDD.n145 0.0755
R656 VDD.n182 VDD.n145 0.0755
R657 VDD.n182 VDD.n181 0.0755
R658 VDD.n314 VDD.n85 0.0755
R659 VDD.n307 VDD.n85 0.0755
R660 VDD.n307 VDD.n306 0.0755
R661 VDD.n306 VDD.n88 0.0755
R662 VDD.n92 VDD.n88 0.0755
R663 VDD.n297 VDD.n92 0.0755
R664 VDD.n297 VDD.n296 0.0755
R665 VDD.n296 VDD.n93 0.0755
R666 VDD.n289 VDD.n93 0.0755
R667 VDD.n289 VDD.n288 0.0755
R668 VDD.n288 VDD.n97 0.0755
R669 VDD.n281 VDD.n97 0.0755
R670 VDD.n281 VDD.n280 0.0755
R671 VDD.n280 VDD.n101 0.0755
R672 VDD.n273 VDD.n101 0.0755
R673 VDD.n273 VDD.n272 0.0755
R674 VDD.n272 VDD.n105 0.0755
R675 VDD.n265 VDD.n105 0.0755
R676 VDD.n265 VDD.n264 0.0755
R677 VDD.n264 VDD.n109 0.0755
R678 VDD.n257 VDD.n109 0.0755
R679 VDD.n257 VDD.n256 0.0755
R680 VDD.n256 VDD.n113 0.0755
R681 VDD.n249 VDD.n113 0.0755
R682 VDD.n249 VDD.n248 0.0755
R683 VDD.n248 VDD.n117 0.0755
R684 VDD.n241 VDD.n117 0.0755
R685 VDD.n241 VDD.n240 0.0755
R686 VDD.n240 VDD.n121 0.0755
R687 VDD.n235 VDD.n234 0.0755
R688 VDD.n234 VDD.n123 0.0755
R689 VDD.n227 VDD.n123 0.0755
R690 VDD.n227 VDD.n226 0.0755
R691 VDD.n226 VDD.n127 0.0755
R692 VDD.n219 VDD.n127 0.0755
R693 VDD.n219 VDD.n218 0.0755
R694 VDD.n218 VDD.n131 0.0755
R695 VDD.n211 VDD.n131 0.0755
R696 VDD.n209 VDD.n135 0.0755
R697 VDD.n203 VDD.n135 0.0755
R698 VDD.n203 VDD.n202 0.0755
R699 VDD.n202 VDD.n201 0.0755
R700 VDD.n201 VDD.n138 0.0755
R701 VDD.n194 VDD.n138 0.0755
R702 VDD.n194 VDD.n193 0.0755
R703 VDD.n193 VDD.n143 0.0755
R704 VDD.n186 VDD.n143 0.0755
R705 VDD.n186 VDD.n185 0.0755
R706 VDD.n185 VDD.n147 0.0755
R707 VDD.n178 VDD.n147 0.0755
R708 VDD.n178 VDD.n177 0.0755
R709 VDD.n177 VDD.n150 0.0755
R710 VDD.n154 VDD.n150 0.0755
R711 VDD.n170 VDD.n154 0.0755
R712 VDD.n170 VDD.n169 0.0755
R713 VDD.n169 VDD.n155 0.0755
R714 VDD.n162 VDD.n155 0.0755
R715 VDD.n162 VDD.n161 0.0755
R716 VDD.n161 VDD.n0 0.0755
R717 VDD.n237 VDD.n236 0.0755
R718 VDD.n204 VDD.n137 0.0755
R719 VDD.n176 VDD.n175 0.0755
R720 VDD.n483 VDD.n482 0.0740876
R721 VDD.n211 VDD.n210 0.071
R722 VDD.n200 VDD.n139 0.071
R723 VDD.n199 VDD.n140 0.071
R724 VDD.n196 VDD.n195 0.071
R725 VDD.n192 VDD.n142 0.071
R726 VDD.n191 VDD.n144 0.071
R727 VDD.n188 VDD.n187 0.071
R728 VDD.n184 VDD.n146 0.071
R729 VDD.n183 VDD.n148 0.071
R730 VDD.n180 VDD.n179 0.071
R731 VDD.n176 VDD.n149 0.071
R732 VDD.n319 VDD.n82 0.0700896
R733 VDD.n315 VDD.n84 0.0666298
R734 VDD.n233 VDD.n122 0.062
R735 VDD.n232 VDD.n124 0.062
R736 VDD.n229 VDD.n228 0.062
R737 VDD.n225 VDD.n126 0.062
R738 VDD.n224 VDD.n128 0.062
R739 VDD.n221 VDD.n220 0.062
R740 VDD.n217 VDD.n130 0.062
R741 VDD.n216 VDD.n132 0.062
R742 VDD.n213 VDD.n212 0.062
R743 VDD.n208 VDD.n134 0.062
R744 VDD.n207 VDD.n136 0.062
R745 VDD.n205 VDD.n204 0.062
R746 VDD.n320 VDD.n81 0.060125
R747 VDD.n324 VDD.n323 0.060125
R748 VDD.n327 VDD.n79 0.060125
R749 VDD.n328 VDD.n77 0.060125
R750 VDD.n332 VDD.n331 0.060125
R751 VDD.n335 VDD.n75 0.060125
R752 VDD.n336 VDD.n73 0.060125
R753 VDD.n340 VDD.n339 0.060125
R754 VDD.n343 VDD.n71 0.060125
R755 VDD.n344 VDD.n69 0.060125
R756 VDD.n348 VDD.n347 0.060125
R757 VDD.n351 VDD.n67 0.060125
R758 VDD.n352 VDD.n65 0.060125
R759 VDD.n356 VDD.n355 0.060125
R760 VDD.n359 VDD.n63 0.060125
R761 VDD.n360 VDD.n61 0.060125
R762 VDD.n364 VDD.n363 0.060125
R763 VDD.n367 VDD.n59 0.060125
R764 VDD.n368 VDD.n57 0.060125
R765 VDD.n372 VDD.n371 0.060125
R766 VDD.n375 VDD.n55 0.060125
R767 VDD.n376 VDD.n53 0.060125
R768 VDD.n380 VDD.n379 0.060125
R769 VDD.n383 VDD.n51 0.060125
R770 VDD.n384 VDD.n49 0.060125
R771 VDD.n388 VDD.n387 0.060125
R772 VDD.n391 VDD.n47 0.060125
R773 VDD.n392 VDD.n45 0.060125
R774 VDD.n396 VDD.n395 0.060125
R775 VDD.n399 VDD.n43 0.060125
R776 VDD.n400 VDD.n41 0.060125
R777 VDD.n404 VDD.n403 0.060125
R778 VDD.n407 VDD.n39 0.060125
R779 VDD.n408 VDD.n37 0.060125
R780 VDD.n412 VDD.n411 0.060125
R781 VDD.n415 VDD.n35 0.060125
R782 VDD.n416 VDD.n33 0.060125
R783 VDD.n420 VDD.n419 0.060125
R784 VDD.n423 VDD.n31 0.060125
R785 VDD.n424 VDD.n29 0.060125
R786 VDD.n428 VDD.n427 0.060125
R787 VDD.n431 VDD.n27 0.060125
R788 VDD.n432 VDD.n25 0.060125
R789 VDD.n436 VDD.n435 0.060125
R790 VDD.n439 VDD.n23 0.060125
R791 VDD.n440 VDD.n21 0.060125
R792 VDD.n444 VDD.n443 0.060125
R793 VDD.n447 VDD.n19 0.060125
R794 VDD.n448 VDD.n17 0.060125
R795 VDD.n452 VDD.n451 0.060125
R796 VDD.n455 VDD.n15 0.060125
R797 VDD.n456 VDD.n13 0.060125
R798 VDD.n460 VDD.n459 0.060125
R799 VDD.n463 VDD.n11 0.060125
R800 VDD.n464 VDD.n9 0.060125
R801 VDD.n468 VDD.n467 0.060125
R802 VDD.n471 VDD.n7 0.060125
R803 VDD.n472 VDD.n5 0.060125
R804 VDD.n477 VDD.n476 0.060125
R805 VDD.n479 VDD.n3 0.060125
R806 VDD.n175 VDD.n174 0.060125
R807 VDD.n172 VDD.n151 0.060125
R808 VDD.n171 VDD.n153 0.060125
R809 VDD.n168 VDD.n167 0.060125
R810 VDD.n164 VDD.n156 0.060125
R811 VDD.n163 VDD.n157 0.060125
R812 VDD.n485 VDD.n484 0.0568929
R813 VDD.n301 VDD.n89 0.056
R814 VDD.n299 VDD.n298 0.056
R815 VDD.n295 VDD.n91 0.056
R816 VDD.n294 VDD.n94 0.056
R817 VDD.n291 VDD.n290 0.056
R818 VDD.n287 VDD.n96 0.056
R819 VDD.n286 VDD.n98 0.056
R820 VDD.n283 VDD.n282 0.056
R821 VDD.n279 VDD.n100 0.056
R822 VDD.n278 VDD.n102 0.056
R823 VDD.n275 VDD.n274 0.056
R824 VDD.n271 VDD.n104 0.056
R825 VDD.n270 VDD.n106 0.056
R826 VDD.n267 VDD.n266 0.056
R827 VDD.n263 VDD.n108 0.056
R828 VDD.n262 VDD.n110 0.056
R829 VDD.n259 VDD.n258 0.056
R830 VDD.n255 VDD.n112 0.056
R831 VDD.n254 VDD.n114 0.056
R832 VDD.n251 VDD.n250 0.056
R833 VDD.n247 VDD.n116 0.056
R834 VDD.n246 VDD.n118 0.056
R835 VDD.n243 VDD.n242 0.056
R836 VDD.n239 VDD.n120 0.056
R837 VDD.n238 VDD.n237 0.056
R838 VDD.t6 VDD.n121 0.055625
R839 VDD.n304 VDD.n302 0.054875
R840 VDD.n313 VDD.n312 0.051125
R841 VDD.n309 VDD.n86 0.051125
R842 VDD.n308 VDD.n87 0.051125
R843 VDD.n159 VDD.n1 0.045875
R844 VDD.n484 VDD.n1 0.0455
R845 VDD.n482 VDD.n480 0.030125
R846 VDD.n160 VDD.n159 0.030125
R847 VDD VDD.n485 0.0285435
R848 VDD.n313 VDD.n84 0.024875
R849 VDD.n312 VDD.n86 0.024875
R850 VDD.n309 VDD.n308 0.024875
R851 VDD.n305 VDD.n87 0.024875
R852 VDD.n305 VDD.n304 0.021125
R853 VDD.n235 VDD.t6 0.020375
R854 VDD.n302 VDD.n301 0.02
R855 VDD.n299 VDD.n89 0.02
R856 VDD.n298 VDD.n91 0.02
R857 VDD.n295 VDD.n294 0.02
R858 VDD.n291 VDD.n94 0.02
R859 VDD.n290 VDD.n96 0.02
R860 VDD.n287 VDD.n286 0.02
R861 VDD.n283 VDD.n98 0.02
R862 VDD.n282 VDD.n100 0.02
R863 VDD.n279 VDD.n278 0.02
R864 VDD.n275 VDD.n102 0.02
R865 VDD.n274 VDD.n104 0.02
R866 VDD.n271 VDD.n270 0.02
R867 VDD.n267 VDD.n106 0.02
R868 VDD.n266 VDD.n108 0.02
R869 VDD.n263 VDD.n262 0.02
R870 VDD.n259 VDD.n110 0.02
R871 VDD.n258 VDD.n112 0.02
R872 VDD.n255 VDD.n254 0.02
R873 VDD.n251 VDD.n114 0.02
R874 VDD.n250 VDD.n116 0.02
R875 VDD.n247 VDD.n246 0.02
R876 VDD.n243 VDD.n118 0.02
R877 VDD.n242 VDD.n120 0.02
R878 VDD.n239 VDD.n238 0.02
R879 VDD.n320 VDD.n319 0.015875
R880 VDD.n323 VDD.n81 0.015875
R881 VDD.n324 VDD.n79 0.015875
R882 VDD.n328 VDD.n327 0.015875
R883 VDD.n331 VDD.n77 0.015875
R884 VDD.n332 VDD.n75 0.015875
R885 VDD.n336 VDD.n335 0.015875
R886 VDD.n339 VDD.n73 0.015875
R887 VDD.n340 VDD.n71 0.015875
R888 VDD.n344 VDD.n343 0.015875
R889 VDD.n347 VDD.n69 0.015875
R890 VDD.n348 VDD.n67 0.015875
R891 VDD.n352 VDD.n351 0.015875
R892 VDD.n355 VDD.n65 0.015875
R893 VDD.n356 VDD.n63 0.015875
R894 VDD.n360 VDD.n359 0.015875
R895 VDD.n363 VDD.n61 0.015875
R896 VDD.n364 VDD.n59 0.015875
R897 VDD.n368 VDD.n367 0.015875
R898 VDD.n371 VDD.n57 0.015875
R899 VDD.n372 VDD.n55 0.015875
R900 VDD.n376 VDD.n375 0.015875
R901 VDD.n379 VDD.n53 0.015875
R902 VDD.n380 VDD.n51 0.015875
R903 VDD.n384 VDD.n383 0.015875
R904 VDD.n387 VDD.n49 0.015875
R905 VDD.n388 VDD.n47 0.015875
R906 VDD.n392 VDD.n391 0.015875
R907 VDD.n395 VDD.n45 0.015875
R908 VDD.n396 VDD.n43 0.015875
R909 VDD.n400 VDD.n399 0.015875
R910 VDD.n403 VDD.n41 0.015875
R911 VDD.n404 VDD.n39 0.015875
R912 VDD.n408 VDD.n407 0.015875
R913 VDD.n411 VDD.n37 0.015875
R914 VDD.n412 VDD.n35 0.015875
R915 VDD.n416 VDD.n415 0.015875
R916 VDD.n419 VDD.n33 0.015875
R917 VDD.n420 VDD.n31 0.015875
R918 VDD.n424 VDD.n423 0.015875
R919 VDD.n427 VDD.n29 0.015875
R920 VDD.n428 VDD.n27 0.015875
R921 VDD.n432 VDD.n431 0.015875
R922 VDD.n435 VDD.n25 0.015875
R923 VDD.n436 VDD.n23 0.015875
R924 VDD.n440 VDD.n439 0.015875
R925 VDD.n443 VDD.n21 0.015875
R926 VDD.n444 VDD.n19 0.015875
R927 VDD.n448 VDD.n447 0.015875
R928 VDD.n451 VDD.n17 0.015875
R929 VDD.n452 VDD.n15 0.015875
R930 VDD.n456 VDD.n455 0.015875
R931 VDD.n459 VDD.n13 0.015875
R932 VDD.n460 VDD.n11 0.015875
R933 VDD.n464 VDD.n463 0.015875
R934 VDD.n467 VDD.n9 0.015875
R935 VDD.n468 VDD.n7 0.015875
R936 VDD.n472 VDD.n471 0.015875
R937 VDD.n476 VDD.n5 0.015875
R938 VDD.n477 VDD.n3 0.015875
R939 VDD.n480 VDD.n479 0.015875
R940 VDD.n174 VDD.n151 0.015875
R941 VDD.n172 VDD.n171 0.015875
R942 VDD.n168 VDD.n153 0.015875
R943 VDD.n167 VDD.n156 0.015875
R944 VDD.n164 VDD.n163 0.015875
R945 VDD.n160 VDD.n157 0.015875
R946 VDD.n236 VDD.n122 0.014
R947 VDD.n233 VDD.n232 0.014
R948 VDD.n229 VDD.n124 0.014
R949 VDD.n228 VDD.n126 0.014
R950 VDD.n225 VDD.n224 0.014
R951 VDD.n221 VDD.n128 0.014
R952 VDD.n220 VDD.n130 0.014
R953 VDD.n217 VDD.n216 0.014
R954 VDD.n213 VDD.n132 0.014
R955 VDD.n212 VDD.n134 0.014
R956 VDD.n208 VDD.n207 0.014
R957 VDD.n205 VDD.n136 0.014
R958 VDD.n210 VDD.n209 0.005
R959 VDD.n139 VDD.n137 0.005
R960 VDD.n200 VDD.n199 0.005
R961 VDD.n196 VDD.n140 0.005
R962 VDD.n195 VDD.n142 0.005
R963 VDD.n192 VDD.n191 0.005
R964 VDD.n188 VDD.n144 0.005
R965 VDD.n187 VDD.n146 0.005
R966 VDD.n184 VDD.n183 0.005
R967 VDD.n180 VDD.n148 0.005
R968 VDD.n179 VDD.n149 0.005
R969 VSS.n130 VSS.n128 929782
R970 VSS.n128 VSS.t51 37693.5
R971 VSS.t54 VSS.n130 30577.3
R972 VSS.t51 VSS.t49 1470.29
R973 VSS.n131 VSS.t40 963.707
R974 VSS.t31 VSS.t54 564.056
R975 VSS.t93 VSS.t36 503.908
R976 VSS.t37 VSS.t171 501.235
R977 VSS.t42 VSS.t68 405.486
R978 VSS.t157 VSS.t42 321.329
R979 VSS.t40 VSS.t67 307.423
R980 VSS.t68 VSS.n128 277.337
R981 VSS.t92 VSS.t111 246.351
R982 VSS.t171 VSS.t169 200.494
R983 VSS.t169 VSS.t167 200.494
R984 VSS.t167 VSS.t165 200.494
R985 VSS.t165 VSS.t163 200.494
R986 VSS.t163 VSS.t161 200.494
R987 VSS.t161 VSS.t159 200.494
R988 VSS.t159 VSS.t93 200.494
R989 VSS.t53 VSS.t39 175.965
R990 VSS.t36 VSS.t66 171.089
R991 VSS.t66 VSS.t65 171.089
R992 VSS.t65 VSS.t35 171.089
R993 VSS.t35 VSS.t34 171.089
R994 VSS.t34 VSS.t64 171.089
R995 VSS.t64 VSS.t63 171.089
R996 VSS.t63 VSS.t33 171.089
R997 VSS.t33 VSS.t32 171.089
R998 VSS.t32 VSS.t62 171.089
R999 VSS.t62 VSS.t61 171.089
R1000 VSS.t61 VSS.t31 171.089
R1001 VSS.t67 VSS.t37 162.957
R1002 VSS.t155 VSS.t157 114.76
R1003 VSS.t151 VSS.t153 114.76
R1004 VSS.t147 VSS.t149 114.76
R1005 VSS.t143 VSS.t145 114.76
R1006 VSS.t139 VSS.t141 114.76
R1007 VSS.t135 VSS.t137 114.76
R1008 VSS.t131 VSS.t133 114.76
R1009 VSS.t127 VSS.t129 114.76
R1010 VSS.t123 VSS.t125 114.76
R1011 VSS.t119 VSS.t121 114.76
R1012 VSS.t115 VSS.t117 114.76
R1013 VSS.t111 VSS.t113 114.76
R1014 VSS.n131 VSS.t49 105.594
R1015 VSS.n130 VSS.t53 101.371
R1016 VSS.t23 VSS.t92 97.9289
R1017 VSS.t22 VSS.t23 97.9289
R1018 VSS.t91 VSS.t22 97.9289
R1019 VSS.t90 VSS.t91 97.9289
R1020 VSS.t21 VSS.t90 97.9289
R1021 VSS.t89 VSS.t20 97.9289
R1022 VSS.t88 VSS.t89 97.9289
R1023 VSS.t18 VSS.t19 97.9289
R1024 VSS.t87 VSS.t18 97.9289
R1025 VSS.t86 VSS.t87 97.9289
R1026 VSS.t17 VSS.t86 97.9289
R1027 VSS.t85 VSS.t16 97.9289
R1028 VSS.t84 VSS.t85 97.9289
R1029 VSS.t15 VSS.t84 97.9289
R1030 VSS.t14 VSS.t15 97.9289
R1031 VSS.t83 VSS.t14 97.9289
R1032 VSS.t82 VSS.t83 97.9289
R1033 VSS.t13 VSS.t82 97.9289
R1034 VSS.t81 VSS.t12 97.9289
R1035 VSS.t80 VSS.t81 97.9289
R1036 VSS.t11 VSS.t80 97.9289
R1037 VSS.t10 VSS.t11 97.9289
R1038 VSS.t79 VSS.t10 97.9289
R1039 VSS.t78 VSS.t79 97.9289
R1040 VSS.t76 VSS.t77 97.9289
R1041 VSS.t6 VSS.t7 97.9289
R1042 VSS.t74 VSS.t75 97.9289
R1043 VSS.t4 VSS.t5 97.9289
R1044 VSS.t72 VSS.t73 97.9289
R1045 VSS.t2 VSS.t3 97.9289
R1046 VSS.t57 VSS.t58 97.9289
R1047 VSS.t27 VSS.t57 97.9289
R1048 VSS.t109 VSS.t76 93.3385
R1049 VSS.t43 VSS.t13 87.9831
R1050 VSS.t3 VSS.t95 85.6879
R1051 VSS.t153 VSS.t155 81.0975
R1052 VSS.t149 VSS.t151 81.0975
R1053 VSS.t145 VSS.t147 81.0975
R1054 VSS.t141 VSS.t143 81.0975
R1055 VSS.t137 VSS.t139 81.0975
R1056 VSS.t133 VSS.t135 81.0975
R1057 VSS.t129 VSS.t131 81.0975
R1058 VSS.t125 VSS.t127 81.0975
R1059 VSS.t121 VSS.t123 81.0975
R1060 VSS.t117 VSS.t119 81.0975
R1061 VSS.t113 VSS.t115 81.0975
R1062 VSS.t105 VSS.t107 81.0975
R1063 VSS.t101 VSS.t103 81.0975
R1064 VSS.t97 VSS.t99 81.0975
R1065 VSS.t45 VSS.t17 63.501
R1066 VSS.t30 VSS.t2 62.7359
R1067 VSS.t60 VSS.t71 62.7359
R1068 VSS.t59 VSS.t70 62.7359
R1069 VSS.t29 VSS.t1 62.7359
R1070 VSS.t28 VSS.t0 62.7359
R1071 VSS.t58 VSS.t69 62.7359
R1072 VSS.t20 VSS.t47 58.9106
R1073 VSS.t77 VSS.t24 53.5551
R1074 VSS.t19 VSS.n129 51.2599
R1075 VSS.n129 VSS.t88 46.6695
R1076 VSS.t47 VSS.t21 39.0189
R1077 VSS.t71 VSS.t30 35.1935
R1078 VSS.t70 VSS.t60 35.1935
R1079 VSS.t1 VSS.t59 35.1935
R1080 VSS.t0 VSS.t29 35.1935
R1081 VSS.t69 VSS.t28 35.1935
R1082 VSS.t16 VSS.t45 34.4285
R1083 VSS.t24 VSS.t8 27.2164
R1084 VSS.t39 VSS.t27 26.0127
R1085 VSS.n139 VSS.t41 24.8138
R1086 VSS.t24 VSS.t9 20.9327
R1087 VSS.t39 VSS.t56 15.4458
R1088 VSS.t39 VSS.t25 15.2658
R1089 VSS.t107 VSS.t6 12.2416
R1090 VSS.t103 VSS.t74 12.2416
R1091 VSS.t99 VSS.t4 12.2416
R1092 VSS.t95 VSS.t72 12.2416
R1093 VSS.t24 VSS.t78 10.7114
R1094 VSS.t12 VSS.t43 9.94636
R1095 VSS.t39 VSS.t55 6.75108
R1096 VSS.t39 VSS.t26 6.15703
R1097 VSS.n347 VSS.n346 5.21897
R1098 VSS.n536 VSS.n535 5.17051
R1099 VSS.t7 VSS.t109 4.5909
R1100 VSS.t75 VSS.t105 4.5909
R1101 VSS.t5 VSS.t101 4.5909
R1102 VSS.t73 VSS.t97 4.5909
R1103 VSS.t53 VSS.t38 3.58529
R1104 VSS.t52 VSS.n118 1.96739
R1105 VSS.n138 VSS.t50 1.96739
R1106 VSS.n156 VSS.t172 1.94182
R1107 VSS.n169 VSS.t94 1.94182
R1108 VSS.n435 VSS.t48 1.81678
R1109 VSS.n477 VSS.t44 1.81678
R1110 VSS.n22 VSS.t110 1.79377
R1111 VSS.n507 VSS.t96 1.79377
R1112 VSS.n426 VSS.t112 1.79377
R1113 VSS.n369 VSS.t158 1.79377
R1114 VSS.n137 VSS.n123 1.64695
R1115 VSS.n448 VSS.n39 1.64695
R1116 VSS.n475 VSS.n474 1.64695
R1117 VSS.n224 VSS.n157 1.62682
R1118 VSS.n163 VSS.n162 1.62682
R1119 VSS.n215 VSS.n164 1.62682
R1120 VSS.n495 VSS.n21 1.62682
R1121 VSS.n498 VSS.n496 1.62682
R1122 VSS.n17 VSS.n16 1.62682
R1123 VSS.n51 VSS.n50 1.62682
R1124 VSS.n417 VSS.n415 1.62682
R1125 VSS.n414 VSS.n55 1.62682
R1126 VSS.n405 VSS.n404 1.62682
R1127 VSS.n403 VSS.n60 1.62682
R1128 VSS.n62 VSS.n61 1.62682
R1129 VSS.n394 VSS.n392 1.62682
R1130 VSS.n67 VSS.n66 1.62682
R1131 VSS.n383 VSS.n381 1.62682
R1132 VSS.n380 VSS.n71 1.62682
R1133 VSS.n371 VSS.n370 1.62682
R1134 VSS.n536 VSS.n1 1.57925
R1135 VSS.n345 VSS.n344 1.5755
R1136 VSS.n258 VSS.n134 1.5755
R1137 VSS.n253 VSS.n252 1.5755
R1138 VSS.n186 VSS.n180 1.5755
R1139 VSS.n452 VSS.n38 1.5755
R1140 VSS.n482 VSS.n481 1.5755
R1141 VSS.n349 VSS.n348 1.5755
R1142 VSS.n440 VSS.n41 1.5755
R1143 VSS.n519 VSS.n8 1.5755
R1144 VSS.n534 VSS.n533 1.5755
R1145 VSS.n490 VSS.n24 1.5755
R1146 VSS.n512 VSS.n11 1.5755
R1147 VSS.n3 VSS.n2 1.5005
R1148 VSS.n531 VSS.n530 1.5005
R1149 VSS.n529 VSS.n528 1.5005
R1150 VSS.n7 VSS.n6 1.5005
R1151 VSS.n523 VSS.n522 1.5005
R1152 VSS.n521 VSS.n520 1.5005
R1153 VSS.n518 VSS.n10 1.5005
R1154 VSS.n517 VSS.n516 1.5005
R1155 VSS.n515 VSS.n514 1.5005
R1156 VSS.n13 VSS.n12 1.5005
R1157 VSS.n509 VSS.n508 1.5005
R1158 VSS.n506 VSS.n505 1.5005
R1159 VSS.n497 VSS.n18 1.5005
R1160 VSS.n500 VSS.n499 1.5005
R1161 VSS.n494 VSS.n493 1.5005
R1162 VSS.n486 VSS.n23 1.5005
R1163 VSS.n488 VSS.n487 1.5005
R1164 VSS.n490 VSS.n489 1.5005
R1165 VSS.n492 VSS.n491 1.5005
R1166 VSS.n20 VSS.n19 1.5005
R1167 VSS.n502 VSS.n501 1.5005
R1168 VSS.n504 VSS.n503 1.5005
R1169 VSS.n15 VSS.n14 1.5005
R1170 VSS.n511 VSS.n510 1.5005
R1171 VSS.n513 VSS.n512 1.5005
R1172 VSS.n9 VSS.n8 1.5005
R1173 VSS.n525 VSS.n524 1.5005
R1174 VSS.n527 VSS.n526 1.5005
R1175 VSS.n5 VSS.n4 1.5005
R1176 VSS.n533 VSS.n532 1.5005
R1177 VSS.n350 VSS.n349 1.5005
R1178 VSS.n83 VSS.n82 1.5005
R1179 VSS.n356 VSS.n355 1.5005
R1180 VSS.n358 VSS.n357 1.5005
R1181 VSS.n79 VSS.n78 1.5005
R1182 VSS.n364 VSS.n363 1.5005
R1183 VSS.n366 VSS.n365 1.5005
R1184 VSS.n75 VSS.n74 1.5005
R1185 VSS.n375 VSS.n374 1.5005
R1186 VSS.n377 VSS.n376 1.5005
R1187 VSS.n70 VSS.n69 1.5005
R1188 VSS.n387 VSS.n386 1.5005
R1189 VSS.n389 VSS.n388 1.5005
R1190 VSS.n65 VSS.n64 1.5005
R1191 VSS.n398 VSS.n397 1.5005
R1192 VSS.n400 VSS.n399 1.5005
R1193 VSS.n59 VSS.n58 1.5005
R1194 VSS.n409 VSS.n408 1.5005
R1195 VSS.n411 VSS.n410 1.5005
R1196 VSS.n54 VSS.n53 1.5005
R1197 VSS.n421 VSS.n420 1.5005
R1198 VSS.n423 VSS.n422 1.5005
R1199 VSS.n49 VSS.n48 1.5005
R1200 VSS.n430 VSS.n429 1.5005
R1201 VSS.n432 VSS.n431 1.5005
R1202 VSS.n45 VSS.n44 1.5005
R1203 VSS.n439 VSS.n438 1.5005
R1204 VSS.n441 VSS.n440 1.5005
R1205 VSS.n452 VSS.n451 1.5005
R1206 VSS.n454 VSS.n453 1.5005
R1207 VSS.n35 VSS.n34 1.5005
R1208 VSS.n461 VSS.n460 1.5005
R1209 VSS.n462 VSS.n32 1.5005
R1210 VSS.n471 VSS.n470 1.5005
R1211 VSS.n469 VSS.n468 1.5005
R1212 VSS.n465 VSS.n463 1.5005
R1213 VSS.n28 VSS.n27 1.5005
R1214 VSS.n481 VSS.n480 1.5005
R1215 VSS.n485 VSS.n484 1.5005
R1216 VSS.n483 VSS.n25 1.5005
R1217 VSS.n476 VSS.n26 1.5005
R1218 VSS.n479 VSS.n478 1.5005
R1219 VSS.n464 VSS.n29 1.5005
R1220 VSS.n467 VSS.n466 1.5005
R1221 VSS.n33 VSS.n31 1.5005
R1222 VSS.n473 VSS.n472 1.5005
R1223 VSS.n459 VSS.n30 1.5005
R1224 VSS.n458 VSS.n457 1.5005
R1225 VSS.n456 VSS.n455 1.5005
R1226 VSS.n37 VSS.n36 1.5005
R1227 VSS.n450 VSS.n449 1.5005
R1228 VSS.n447 VSS.n446 1.5005
R1229 VSS.n445 VSS.n444 1.5005
R1230 VSS.n443 VSS.n442 1.5005
R1231 VSS.n43 VSS.n42 1.5005
R1232 VSS.n437 VSS.n436 1.5005
R1233 VSS.n434 VSS.n433 1.5005
R1234 VSS.n47 VSS.n46 1.5005
R1235 VSS.n428 VSS.n427 1.5005
R1236 VSS.n425 VSS.n424 1.5005
R1237 VSS.n416 VSS.n52 1.5005
R1238 VSS.n419 VSS.n418 1.5005
R1239 VSS.n413 VSS.n412 1.5005
R1240 VSS.n57 VSS.n56 1.5005
R1241 VSS.n407 VSS.n406 1.5005
R1242 VSS.n402 VSS.n401 1.5005
R1243 VSS.n393 VSS.n63 1.5005
R1244 VSS.n396 VSS.n395 1.5005
R1245 VSS.n391 VSS.n390 1.5005
R1246 VSS.n382 VSS.n68 1.5005
R1247 VSS.n385 VSS.n384 1.5005
R1248 VSS.n379 VSS.n378 1.5005
R1249 VSS.n73 VSS.n72 1.5005
R1250 VSS.n373 VSS.n372 1.5005
R1251 VSS.n368 VSS.n367 1.5005
R1252 VSS.n77 VSS.n76 1.5005
R1253 VSS.n362 VSS.n361 1.5005
R1254 VSS.n360 VSS.n359 1.5005
R1255 VSS.n81 VSS.n80 1.5005
R1256 VSS.n354 VSS.n353 1.5005
R1257 VSS.n352 VSS.n351 1.5005
R1258 VSS.n85 VSS.n84 1.5005
R1259 VSS.n186 VSS.n185 1.5005
R1260 VSS.n188 VSS.n187 1.5005
R1261 VSS.n177 VSS.n176 1.5005
R1262 VSS.n194 VSS.n193 1.5005
R1263 VSS.n196 VSS.n195 1.5005
R1264 VSS.n173 VSS.n172 1.5005
R1265 VSS.n202 VSS.n201 1.5005
R1266 VSS.n204 VSS.n203 1.5005
R1267 VSS.n168 VSS.n167 1.5005
R1268 VSS.n210 VSS.n209 1.5005
R1269 VSS.n212 VSS.n211 1.5005
R1270 VSS.n161 VSS.n160 1.5005
R1271 VSS.n219 VSS.n218 1.5005
R1272 VSS.n221 VSS.n220 1.5005
R1273 VSS.n155 VSS.n154 1.5005
R1274 VSS.n228 VSS.n227 1.5005
R1275 VSS.n230 VSS.n229 1.5005
R1276 VSS.n151 VSS.n150 1.5005
R1277 VSS.n236 VSS.n235 1.5005
R1278 VSS.n238 VSS.n237 1.5005
R1279 VSS.n147 VSS.n146 1.5005
R1280 VSS.n244 VSS.n243 1.5005
R1281 VSS.n246 VSS.n245 1.5005
R1282 VSS.n143 VSS.n142 1.5005
R1283 VSS.n252 VSS.n251 1.5005
R1284 VSS.n135 VSS.n134 1.5005
R1285 VSS.n264 VSS.n263 1.5005
R1286 VSS.n266 VSS.n265 1.5005
R1287 VSS.n126 VSS.n125 1.5005
R1288 VSS.n272 VSS.n271 1.5005
R1289 VSS.n274 VSS.n273 1.5005
R1290 VSS.n122 VSS.n121 1.5005
R1291 VSS.n280 VSS.n279 1.5005
R1292 VSS.n282 VSS.n281 1.5005
R1293 VSS.n117 VSS.n116 1.5005
R1294 VSS.n288 VSS.n287 1.5005
R1295 VSS.n290 VSS.n289 1.5005
R1296 VSS.n113 VSS.n112 1.5005
R1297 VSS.n296 VSS.n295 1.5005
R1298 VSS.n298 VSS.n297 1.5005
R1299 VSS.n109 VSS.n108 1.5005
R1300 VSS.n304 VSS.n303 1.5005
R1301 VSS.n306 VSS.n305 1.5005
R1302 VSS.n105 VSS.n104 1.5005
R1303 VSS.n312 VSS.n311 1.5005
R1304 VSS.n314 VSS.n313 1.5005
R1305 VSS.n101 VSS.n100 1.5005
R1306 VSS.n320 VSS.n319 1.5005
R1307 VSS.n322 VSS.n321 1.5005
R1308 VSS.n97 VSS.n96 1.5005
R1309 VSS.n328 VSS.n327 1.5005
R1310 VSS.n330 VSS.n329 1.5005
R1311 VSS.n93 VSS.n92 1.5005
R1312 VSS.n336 VSS.n335 1.5005
R1313 VSS.n338 VSS.n337 1.5005
R1314 VSS.n89 VSS.n88 1.5005
R1315 VSS.n344 VSS.n343 1.5005
R1316 VSS.n1 VSS.n0 1.5005
R1317 VSS.n182 VSS.n181 1.5005
R1318 VSS.n184 VSS.n183 1.5005
R1319 VSS.n179 VSS.n178 1.5005
R1320 VSS.n190 VSS.n189 1.5005
R1321 VSS.n192 VSS.n191 1.5005
R1322 VSS.n175 VSS.n174 1.5005
R1323 VSS.n198 VSS.n197 1.5005
R1324 VSS.n200 VSS.n199 1.5005
R1325 VSS.n171 VSS.n170 1.5005
R1326 VSS.n206 VSS.n205 1.5005
R1327 VSS.n208 VSS.n207 1.5005
R1328 VSS.n166 VSS.n165 1.5005
R1329 VSS.n214 VSS.n213 1.5005
R1330 VSS.n217 VSS.n216 1.5005
R1331 VSS.n159 VSS.n158 1.5005
R1332 VSS.n223 VSS.n222 1.5005
R1333 VSS.n226 VSS.n225 1.5005
R1334 VSS.n153 VSS.n152 1.5005
R1335 VSS.n232 VSS.n231 1.5005
R1336 VSS.n234 VSS.n233 1.5005
R1337 VSS.n149 VSS.n148 1.5005
R1338 VSS.n240 VSS.n239 1.5005
R1339 VSS.n242 VSS.n241 1.5005
R1340 VSS.n145 VSS.n144 1.5005
R1341 VSS.n248 VSS.n247 1.5005
R1342 VSS.n250 VSS.n249 1.5005
R1343 VSS.n141 VSS.n140 1.5005
R1344 VSS.n255 VSS.n254 1.5005
R1345 VSS.n257 VSS.n256 1.5005
R1346 VSS.n260 VSS.n259 1.5005
R1347 VSS.n262 VSS.n261 1.5005
R1348 VSS.n136 VSS.n133 1.5005
R1349 VSS.n268 VSS.n267 1.5005
R1350 VSS.n270 VSS.n269 1.5005
R1351 VSS.n127 VSS.n124 1.5005
R1352 VSS.n276 VSS.n275 1.5005
R1353 VSS.n278 VSS.n277 1.5005
R1354 VSS.n120 VSS.n119 1.5005
R1355 VSS.n284 VSS.n283 1.5005
R1356 VSS.n286 VSS.n285 1.5005
R1357 VSS.n115 VSS.n114 1.5005
R1358 VSS.n292 VSS.n291 1.5005
R1359 VSS.n294 VSS.n293 1.5005
R1360 VSS.n111 VSS.n110 1.5005
R1361 VSS.n300 VSS.n299 1.5005
R1362 VSS.n302 VSS.n301 1.5005
R1363 VSS.n107 VSS.n106 1.5005
R1364 VSS.n308 VSS.n307 1.5005
R1365 VSS.n310 VSS.n309 1.5005
R1366 VSS.n103 VSS.n102 1.5005
R1367 VSS.n316 VSS.n315 1.5005
R1368 VSS.n318 VSS.n317 1.5005
R1369 VSS.n99 VSS.n98 1.5005
R1370 VSS.n324 VSS.n323 1.5005
R1371 VSS.n326 VSS.n325 1.5005
R1372 VSS.n95 VSS.n94 1.5005
R1373 VSS.n332 VSS.n331 1.5005
R1374 VSS.n334 VSS.n333 1.5005
R1375 VSS.n91 VSS.n90 1.5005
R1376 VSS.n340 VSS.n339 1.5005
R1377 VSS.n342 VSS.n341 1.5005
R1378 VSS.n87 VSS.n86 1.5005
R1379 VSS.n346 VSS.n86 0.591199
R1380 VSS.n347 VSS.n84 0.591199
R1381 VSS.n535 VSS.n2 0.585263
R1382 VSS.n137 VSS.t52 0.320948
R1383 VSS.t50 VSS.n137 0.320948
R1384 VSS.n157 VSS.t170 0.3155
R1385 VSS.n157 VSS.t168 0.3155
R1386 VSS.n162 VSS.t166 0.3155
R1387 VSS.n162 VSS.t164 0.3155
R1388 VSS.n164 VSS.t162 0.3155
R1389 VSS.n164 VSS.t160 0.3155
R1390 VSS.t48 VSS.n39 0.179951
R1391 VSS.n39 VSS.t46 0.179951
R1392 VSS.n475 VSS.t46 0.179951
R1393 VSS.t44 VSS.n475 0.179951
R1394 VSS.n21 VSS.t108 0.1769
R1395 VSS.n21 VSS.t106 0.1769
R1396 VSS.n496 VSS.t104 0.1769
R1397 VSS.n496 VSS.t102 0.1769
R1398 VSS.n16 VSS.t100 0.1769
R1399 VSS.n16 VSS.t98 0.1769
R1400 VSS.n50 VSS.t116 0.1769
R1401 VSS.n50 VSS.t114 0.1769
R1402 VSS.n415 VSS.t120 0.1769
R1403 VSS.n415 VSS.t118 0.1769
R1404 VSS.n55 VSS.t124 0.1769
R1405 VSS.n55 VSS.t122 0.1769
R1406 VSS.n404 VSS.t128 0.1769
R1407 VSS.n404 VSS.t126 0.1769
R1408 VSS.n60 VSS.t132 0.1769
R1409 VSS.n60 VSS.t130 0.1769
R1410 VSS.n61 VSS.t136 0.1769
R1411 VSS.n61 VSS.t134 0.1769
R1412 VSS.n392 VSS.t140 0.1769
R1413 VSS.n392 VSS.t138 0.1769
R1414 VSS.n66 VSS.t144 0.1769
R1415 VSS.n66 VSS.t142 0.1769
R1416 VSS.n381 VSS.t148 0.1769
R1417 VSS.n381 VSS.t146 0.1769
R1418 VSS.n71 VSS.t152 0.1769
R1419 VSS.n71 VSS.t150 0.1769
R1420 VSS.n370 VSS.t156 0.1769
R1421 VSS.n370 VSS.t154 0.1769
R1422 VSS.n535 VSS.n534 0.117112
R1423 VSS.n346 VSS.n345 0.116614
R1424 VSS.n348 VSS.n347 0.0819264
R1425 VSS.n344 VSS.n88 0.0755
R1426 VSS.n337 VSS.n88 0.0755
R1427 VSS.n337 VSS.n336 0.0755
R1428 VSS.n336 VSS.n92 0.0755
R1429 VSS.n329 VSS.n92 0.0755
R1430 VSS.n329 VSS.n328 0.0755
R1431 VSS.n328 VSS.n96 0.0755
R1432 VSS.n321 VSS.n96 0.0755
R1433 VSS.n321 VSS.n320 0.0755
R1434 VSS.n320 VSS.n100 0.0755
R1435 VSS.n313 VSS.n100 0.0755
R1436 VSS.n313 VSS.n312 0.0755
R1437 VSS.n312 VSS.n104 0.0755
R1438 VSS.n305 VSS.n104 0.0755
R1439 VSS.n305 VSS.n304 0.0755
R1440 VSS.n304 VSS.n108 0.0755
R1441 VSS.n297 VSS.n108 0.0755
R1442 VSS.n297 VSS.n296 0.0755
R1443 VSS.n296 VSS.n112 0.0755
R1444 VSS.n289 VSS.n112 0.0755
R1445 VSS.n289 VSS.n288 0.0755
R1446 VSS.n288 VSS.n116 0.0755
R1447 VSS.n281 VSS.n116 0.0755
R1448 VSS.n281 VSS.n280 0.0755
R1449 VSS.n280 VSS.n121 0.0755
R1450 VSS.n273 VSS.n121 0.0755
R1451 VSS.n273 VSS.n272 0.0755
R1452 VSS.n272 VSS.n125 0.0755
R1453 VSS.n265 VSS.n125 0.0755
R1454 VSS.n265 VSS.n264 0.0755
R1455 VSS.n264 VSS.n134 0.0755
R1456 VSS.n252 VSS.n142 0.0755
R1457 VSS.n245 VSS.n142 0.0755
R1458 VSS.n245 VSS.n244 0.0755
R1459 VSS.n244 VSS.n146 0.0755
R1460 VSS.n237 VSS.n146 0.0755
R1461 VSS.n237 VSS.n236 0.0755
R1462 VSS.n236 VSS.n150 0.0755
R1463 VSS.n229 VSS.n150 0.0755
R1464 VSS.n229 VSS.n228 0.0755
R1465 VSS.n228 VSS.n154 0.0755
R1466 VSS.n220 VSS.n154 0.0755
R1467 VSS.n220 VSS.n219 0.0755
R1468 VSS.n219 VSS.n160 0.0755
R1469 VSS.n211 VSS.n160 0.0755
R1470 VSS.n211 VSS.n210 0.0755
R1471 VSS.n210 VSS.n167 0.0755
R1472 VSS.n203 VSS.n167 0.0755
R1473 VSS.n203 VSS.n202 0.0755
R1474 VSS.n202 VSS.n172 0.0755
R1475 VSS.n195 VSS.n172 0.0755
R1476 VSS.n195 VSS.n194 0.0755
R1477 VSS.n194 VSS.n176 0.0755
R1478 VSS.n187 VSS.n176 0.0755
R1479 VSS.n187 VSS.n186 0.0755
R1480 VSS.n453 VSS.n452 0.0755
R1481 VSS.n453 VSS.n34 0.0755
R1482 VSS.n461 VSS.n34 0.0755
R1483 VSS.n462 VSS.n461 0.0755
R1484 VSS.n470 VSS.n462 0.0755
R1485 VSS.n470 VSS.n469 0.0755
R1486 VSS.n469 VSS.n463 0.0755
R1487 VSS.n463 VSS.n27 0.0755
R1488 VSS.n481 VSS.n27 0.0755
R1489 VSS.n349 VSS.n82 0.0755
R1490 VSS.n356 VSS.n82 0.0755
R1491 VSS.n357 VSS.n356 0.0755
R1492 VSS.n357 VSS.n78 0.0755
R1493 VSS.n364 VSS.n78 0.0755
R1494 VSS.n365 VSS.n364 0.0755
R1495 VSS.n365 VSS.n74 0.0755
R1496 VSS.n375 VSS.n74 0.0755
R1497 VSS.n376 VSS.n375 0.0755
R1498 VSS.n376 VSS.n69 0.0755
R1499 VSS.n387 VSS.n69 0.0755
R1500 VSS.n388 VSS.n387 0.0755
R1501 VSS.n388 VSS.n64 0.0755
R1502 VSS.n398 VSS.n64 0.0755
R1503 VSS.n399 VSS.n398 0.0755
R1504 VSS.n399 VSS.n58 0.0755
R1505 VSS.n409 VSS.n58 0.0755
R1506 VSS.n410 VSS.n409 0.0755
R1507 VSS.n410 VSS.n53 0.0755
R1508 VSS.n421 VSS.n53 0.0755
R1509 VSS.n422 VSS.n421 0.0755
R1510 VSS.n422 VSS.n48 0.0755
R1511 VSS.n430 VSS.n48 0.0755
R1512 VSS.n431 VSS.n430 0.0755
R1513 VSS.n431 VSS.n44 0.0755
R1514 VSS.n439 VSS.n44 0.0755
R1515 VSS.n440 VSS.n439 0.0755
R1516 VSS.n525 VSS.n8 0.0755
R1517 VSS.n526 VSS.n525 0.0755
R1518 VSS.n526 VSS.n4 0.0755
R1519 VSS.n533 VSS.n4 0.0755
R1520 VSS.n491 VSS.n490 0.0755
R1521 VSS.n491 VSS.n19 0.0755
R1522 VSS.n502 VSS.n19 0.0755
R1523 VSS.n503 VSS.n502 0.0755
R1524 VSS.n503 VSS.n14 0.0755
R1525 VSS.n511 VSS.n14 0.0755
R1526 VSS.n512 VSS.n511 0.0755
R1527 VSS.n341 VSS.n86 0.0755
R1528 VSS.n341 VSS.n340 0.0755
R1529 VSS.n340 VSS.n90 0.0755
R1530 VSS.n333 VSS.n90 0.0755
R1531 VSS.n333 VSS.n332 0.0755
R1532 VSS.n332 VSS.n94 0.0755
R1533 VSS.n325 VSS.n94 0.0755
R1534 VSS.n325 VSS.n324 0.0755
R1535 VSS.n324 VSS.n98 0.0755
R1536 VSS.n317 VSS.n98 0.0755
R1537 VSS.n317 VSS.n316 0.0755
R1538 VSS.n316 VSS.n102 0.0755
R1539 VSS.n309 VSS.n102 0.0755
R1540 VSS.n309 VSS.n308 0.0755
R1541 VSS.n308 VSS.n106 0.0755
R1542 VSS.n301 VSS.n106 0.0755
R1543 VSS.n301 VSS.n300 0.0755
R1544 VSS.n300 VSS.n110 0.0755
R1545 VSS.n293 VSS.n110 0.0755
R1546 VSS.n293 VSS.n292 0.0755
R1547 VSS.n292 VSS.n114 0.0755
R1548 VSS.n285 VSS.n284 0.0755
R1549 VSS.n284 VSS.n119 0.0755
R1550 VSS.n277 VSS.n119 0.0755
R1551 VSS.n277 VSS.n276 0.0755
R1552 VSS.n269 VSS.n127 0.0755
R1553 VSS.n269 VSS.n268 0.0755
R1554 VSS.n261 VSS.n136 0.0755
R1555 VSS.n261 VSS.n260 0.0755
R1556 VSS.n256 VSS.n255 0.0755
R1557 VSS.n255 VSS.n140 0.0755
R1558 VSS.n249 VSS.n140 0.0755
R1559 VSS.n249 VSS.n248 0.0755
R1560 VSS.n248 VSS.n144 0.0755
R1561 VSS.n241 VSS.n144 0.0755
R1562 VSS.n241 VSS.n240 0.0755
R1563 VSS.n240 VSS.n148 0.0755
R1564 VSS.n233 VSS.n148 0.0755
R1565 VSS.n233 VSS.n232 0.0755
R1566 VSS.n232 VSS.n152 0.0755
R1567 VSS.n223 VSS.n158 0.0755
R1568 VSS.n214 VSS.n165 0.0755
R1569 VSS.n207 VSS.n206 0.0755
R1570 VSS.n206 VSS.n170 0.0755
R1571 VSS.n199 VSS.n170 0.0755
R1572 VSS.n199 VSS.n198 0.0755
R1573 VSS.n198 VSS.n174 0.0755
R1574 VSS.n191 VSS.n174 0.0755
R1575 VSS.n191 VSS.n190 0.0755
R1576 VSS.n190 VSS.n178 0.0755
R1577 VSS.n183 VSS.n178 0.0755
R1578 VSS.n183 VSS.n182 0.0755
R1579 VSS.n182 VSS.n1 0.0755
R1580 VSS.n352 VSS.n84 0.0755
R1581 VSS.n353 VSS.n352 0.0755
R1582 VSS.n353 VSS.n80 0.0755
R1583 VSS.n360 VSS.n80 0.0755
R1584 VSS.n361 VSS.n360 0.0755
R1585 VSS.n361 VSS.n76 0.0755
R1586 VSS.n368 VSS.n76 0.0755
R1587 VSS.n379 VSS.n72 0.0755
R1588 VSS.n395 VSS.n391 0.0755
R1589 VSS.n413 VSS.n56 0.0755
R1590 VSS.n427 VSS.n46 0.0755
R1591 VSS.n434 VSS.n46 0.0755
R1592 VSS.n436 VSS.n42 0.0755
R1593 VSS.n443 VSS.n42 0.0755
R1594 VSS.n444 VSS.n443 0.0755
R1595 VSS.n449 VSS.n36 0.0755
R1596 VSS.n456 VSS.n36 0.0755
R1597 VSS.n457 VSS.n456 0.0755
R1598 VSS.n457 VSS.n30 0.0755
R1599 VSS.n473 VSS.n31 0.0755
R1600 VSS.n466 VSS.n31 0.0755
R1601 VSS.n466 VSS.n29 0.0755
R1602 VSS.n478 VSS.n29 0.0755
R1603 VSS.n476 VSS.n25 0.0755
R1604 VSS.n485 VSS.n25 0.0755
R1605 VSS.n487 VSS.n485 0.0755
R1606 VSS.n487 VSS.n486 0.0755
R1607 VSS.n508 VSS.n506 0.0755
R1608 VSS.n515 VSS.n12 0.0755
R1609 VSS.n516 VSS.n515 0.0755
R1610 VSS.n516 VSS.n10 0.0755
R1611 VSS.n521 VSS.n10 0.0755
R1612 VSS.n522 VSS.n521 0.0755
R1613 VSS.n522 VSS.n6 0.0755
R1614 VSS.n529 VSS.n6 0.0755
R1615 VSS.n530 VSS.n529 0.0755
R1616 VSS.n530 VSS.n2 0.0755
R1617 VSS.n446 VSS.n445 0.0755
R1618 VSS.n484 VSS.n483 0.0755
R1619 VSS.n518 VSS.n517 0.0755
R1620 VSS.n181 VSS.n0 0.0755
R1621 VSS.n394 VSS.n393 0.075125
R1622 VSS.n497 VSS.n17 0.073625
R1623 VSS.n426 VSS.n425 0.0723125
R1624 VSS.n478 VSS.n477 0.0723125
R1625 VSS.n488 VSS.n24 0.071
R1626 VSS.n489 VSS.n23 0.071
R1627 VSS.n493 VSS.n492 0.071
R1628 VSS.n500 VSS.n20 0.071
R1629 VSS.n501 VSS.n18 0.071
R1630 VSS.n505 VSS.n504 0.071
R1631 VSS.n509 VSS.n15 0.071
R1632 VSS.n510 VSS.n13 0.071
R1633 VSS.n514 VSS.n513 0.071
R1634 VSS.n517 VSS.n11 0.071
R1635 VSS.n285 VSS.n118 0.06875
R1636 VSS.n256 VSS.n138 0.06875
R1637 VSS.n225 VSS.n156 0.06875
R1638 VSS.n216 VSS.n163 0.06875
R1639 VSS.n207 VSS.n169 0.06875
R1640 VSS.n372 VSS.n371 0.066875
R1641 VSS.n418 VSS.n414 0.066125
R1642 VSS.n436 VSS.n435 0.0655625
R1643 VSS.n494 VSS.n22 0.0648125
R1644 VSS.n406 VSS.n405 0.063875
R1645 VSS.n384 VSS.n380 0.063125
R1646 VSS.n450 VSS.n38 0.062
R1647 VSS.n451 VSS.n37 0.062
R1648 VSS.n455 VSS.n454 0.062
R1649 VSS.n458 VSS.n35 0.062
R1650 VSS.n460 VSS.n459 0.062
R1651 VSS.n472 VSS.n32 0.062
R1652 VSS.n471 VSS.n33 0.062
R1653 VSS.n468 VSS.n467 0.062
R1654 VSS.n465 VSS.n464 0.062
R1655 VSS.n479 VSS.n28 0.062
R1656 VSS.n480 VSS.n26 0.062
R1657 VSS.n483 VSS.n482 0.062
R1658 VSS.n507 VSS.n12 0.0569375
R1659 VSS.n348 VSS.n85 0.056
R1660 VSS.n351 VSS.n350 0.056
R1661 VSS.n354 VSS.n83 0.056
R1662 VSS.n355 VSS.n81 0.056
R1663 VSS.n359 VSS.n358 0.056
R1664 VSS.n362 VSS.n79 0.056
R1665 VSS.n363 VSS.n77 0.056
R1666 VSS.n367 VSS.n366 0.056
R1667 VSS.n373 VSS.n75 0.056
R1668 VSS.n374 VSS.n73 0.056
R1669 VSS.n378 VSS.n377 0.056
R1670 VSS.n385 VSS.n70 0.056
R1671 VSS.n386 VSS.n68 0.056
R1672 VSS.n390 VSS.n389 0.056
R1673 VSS.n396 VSS.n65 0.056
R1674 VSS.n397 VSS.n63 0.056
R1675 VSS.n401 VSS.n400 0.056
R1676 VSS.n407 VSS.n59 0.056
R1677 VSS.n408 VSS.n57 0.056
R1678 VSS.n412 VSS.n411 0.056
R1679 VSS.n419 VSS.n54 0.056
R1680 VSS.n420 VSS.n52 0.056
R1681 VSS.n424 VSS.n423 0.056
R1682 VSS.n428 VSS.n49 0.056
R1683 VSS.n429 VSS.n47 0.056
R1684 VSS.n433 VSS.n432 0.056
R1685 VSS.n437 VSS.n45 0.056
R1686 VSS.n438 VSS.n43 0.056
R1687 VSS.n442 VSS.n441 0.056
R1688 VSS.n445 VSS.n41 0.056
R1689 VSS.n268 VSS.n132 0.055625
R1690 VSS.n444 VSS.n40 0.055625
R1691 VSS.n382 VSS.n67 0.054875
R1692 VSS VSS.n0 0.054875
R1693 VSS.n343 VSS.n87 0.0546875
R1694 VSS.n342 VSS.n89 0.0546875
R1695 VSS.n339 VSS.n338 0.0546875
R1696 VSS.n335 VSS.n91 0.0546875
R1697 VSS.n334 VSS.n93 0.0546875
R1698 VSS.n331 VSS.n330 0.0546875
R1699 VSS.n327 VSS.n95 0.0546875
R1700 VSS.n326 VSS.n97 0.0546875
R1701 VSS.n323 VSS.n322 0.0546875
R1702 VSS.n319 VSS.n99 0.0546875
R1703 VSS.n318 VSS.n101 0.0546875
R1704 VSS.n315 VSS.n314 0.0546875
R1705 VSS.n311 VSS.n103 0.0546875
R1706 VSS.n310 VSS.n105 0.0546875
R1707 VSS.n307 VSS.n306 0.0546875
R1708 VSS.n303 VSS.n107 0.0546875
R1709 VSS.n302 VSS.n109 0.0546875
R1710 VSS.n299 VSS.n298 0.0546875
R1711 VSS.n295 VSS.n111 0.0546875
R1712 VSS.n294 VSS.n113 0.0546875
R1713 VSS.n291 VSS.n290 0.0546875
R1714 VSS.n287 VSS.n115 0.0546875
R1715 VSS.n286 VSS.n117 0.0546875
R1716 VSS.n283 VSS.n282 0.0546875
R1717 VSS.n279 VSS.n120 0.0546875
R1718 VSS.n278 VSS.n122 0.0546875
R1719 VSS.n275 VSS.n274 0.0546875
R1720 VSS.n271 VSS.n124 0.0546875
R1721 VSS.n270 VSS.n126 0.0546875
R1722 VSS.n267 VSS.n266 0.0546875
R1723 VSS.n263 VSS.n133 0.0546875
R1724 VSS.n262 VSS.n135 0.0546875
R1725 VSS.n259 VSS.n258 0.0546875
R1726 VSS.n402 VSS.n62 0.054125
R1727 VSS.n499 VSS.n498 0.052625
R1728 VSS.n416 VSS.n51 0.051875
R1729 VSS.n474 VSS.n30 0.051875
R1730 VSS.n254 VSS.n139 0.0513125
R1731 VSS.n520 VSS.n519 0.04925
R1732 VSS.n523 VSS.n9 0.04925
R1733 VSS.n524 VSS.n7 0.04925
R1734 VSS.n528 VSS.n527 0.04925
R1735 VSS.n531 VSS.n5 0.04925
R1736 VSS.n532 VSS.n3 0.04925
R1737 VSS.n253 VSS.n141 0.04925
R1738 VSS.n251 VSS.n250 0.04925
R1739 VSS.n247 VSS.n143 0.04925
R1740 VSS.n246 VSS.n145 0.04925
R1741 VSS.n243 VSS.n242 0.04925
R1742 VSS.n239 VSS.n147 0.04925
R1743 VSS.n238 VSS.n149 0.04925
R1744 VSS.n235 VSS.n234 0.04925
R1745 VSS.n231 VSS.n151 0.04925
R1746 VSS.n230 VSS.n153 0.04925
R1747 VSS.n227 VSS.n226 0.04925
R1748 VSS.n222 VSS.n155 0.04925
R1749 VSS.n221 VSS.n159 0.04925
R1750 VSS.n218 VSS.n217 0.04925
R1751 VSS.n213 VSS.n161 0.04925
R1752 VSS.n212 VSS.n166 0.04925
R1753 VSS.n209 VSS.n208 0.04925
R1754 VSS.n205 VSS.n168 0.04925
R1755 VSS.n204 VSS.n171 0.04925
R1756 VSS.n201 VSS.n200 0.04925
R1757 VSS.n197 VSS.n173 0.04925
R1758 VSS.n196 VSS.n175 0.04925
R1759 VSS.n193 VSS.n192 0.04925
R1760 VSS.n189 VSS.n177 0.04925
R1761 VSS.n188 VSS.n179 0.04925
R1762 VSS.n185 VSS.n184 0.04925
R1763 VSS.n181 VSS.n180 0.04925
R1764 VSS.n369 VSS.n368 0.0464375
R1765 VSS.n417 VSS.n416 0.045125
R1766 VSS.n449 VSS.n448 0.045125
R1767 VSS.n276 VSS.n123 0.04475
R1768 VSS.n225 VSS.n224 0.04475
R1769 VSS.n216 VSS.n215 0.04475
R1770 VSS.n499 VSS.n495 0.044375
R1771 VSS.n403 VSS.n402 0.042875
R1772 VSS.n383 VSS.n382 0.042125
R1773 VSS.n132 VSS.n131 0.0372491
R1774 VSS.n129 VSS.n40 0.0372491
R1775 VSS.n384 VSS.n383 0.033875
R1776 VSS.n406 VSS.n403 0.033125
R1777 VSS.n495 VSS.n494 0.031625
R1778 VSS.n127 VSS.n123 0.03125
R1779 VSS.n224 VSS.n223 0.03125
R1780 VSS.n215 VSS.n214 0.03125
R1781 VSS.n418 VSS.n417 0.030875
R1782 VSS.n448 VSS.n447 0.030875
R1783 VSS.n372 VSS.n369 0.0295625
R1784 VSS.n519 VSS.n518 0.02675
R1785 VSS.n520 VSS.n9 0.02675
R1786 VSS.n524 VSS.n523 0.02675
R1787 VSS.n527 VSS.n7 0.02675
R1788 VSS.n528 VSS.n5 0.02675
R1789 VSS.n532 VSS.n531 0.02675
R1790 VSS.n534 VSS.n3 0.02675
R1791 VSS.n254 VSS.n253 0.02675
R1792 VSS.n251 VSS.n141 0.02675
R1793 VSS.n250 VSS.n143 0.02675
R1794 VSS.n247 VSS.n246 0.02675
R1795 VSS.n243 VSS.n145 0.02675
R1796 VSS.n242 VSS.n147 0.02675
R1797 VSS.n239 VSS.n238 0.02675
R1798 VSS.n235 VSS.n149 0.02675
R1799 VSS.n234 VSS.n151 0.02675
R1800 VSS.n231 VSS.n230 0.02675
R1801 VSS.n227 VSS.n153 0.02675
R1802 VSS.n226 VSS.n155 0.02675
R1803 VSS.n222 VSS.n221 0.02675
R1804 VSS.n218 VSS.n159 0.02675
R1805 VSS.n217 VSS.n161 0.02675
R1806 VSS.n213 VSS.n212 0.02675
R1807 VSS.n209 VSS.n166 0.02675
R1808 VSS.n208 VSS.n168 0.02675
R1809 VSS.n205 VSS.n204 0.02675
R1810 VSS.n201 VSS.n171 0.02675
R1811 VSS.n200 VSS.n173 0.02675
R1812 VSS.n197 VSS.n196 0.02675
R1813 VSS.n193 VSS.n175 0.02675
R1814 VSS.n192 VSS.n177 0.02675
R1815 VSS.n189 VSS.n188 0.02675
R1816 VSS.n185 VSS.n179 0.02675
R1817 VSS.n184 VSS.n180 0.02675
R1818 VSS.n257 VSS.n139 0.0246875
R1819 VSS.n425 VSS.n51 0.024125
R1820 VSS.n474 VSS.n473 0.024125
R1821 VSS.n498 VSS.n497 0.023375
R1822 VSS.n393 VSS.n62 0.021875
R1823 VSS.n345 VSS.n87 0.0213125
R1824 VSS.n343 VSS.n342 0.0213125
R1825 VSS.n339 VSS.n89 0.0213125
R1826 VSS.n338 VSS.n91 0.0213125
R1827 VSS.n335 VSS.n334 0.0213125
R1828 VSS.n331 VSS.n93 0.0213125
R1829 VSS.n330 VSS.n95 0.0213125
R1830 VSS.n327 VSS.n326 0.0213125
R1831 VSS.n323 VSS.n97 0.0213125
R1832 VSS.n322 VSS.n99 0.0213125
R1833 VSS.n319 VSS.n318 0.0213125
R1834 VSS.n315 VSS.n101 0.0213125
R1835 VSS.n314 VSS.n103 0.0213125
R1836 VSS.n311 VSS.n310 0.0213125
R1837 VSS.n307 VSS.n105 0.0213125
R1838 VSS.n306 VSS.n107 0.0213125
R1839 VSS.n303 VSS.n302 0.0213125
R1840 VSS.n299 VSS.n109 0.0213125
R1841 VSS.n298 VSS.n111 0.0213125
R1842 VSS.n295 VSS.n294 0.0213125
R1843 VSS.n291 VSS.n113 0.0213125
R1844 VSS.n290 VSS.n115 0.0213125
R1845 VSS.n287 VSS.n286 0.0213125
R1846 VSS.n283 VSS.n117 0.0213125
R1847 VSS.n282 VSS.n120 0.0213125
R1848 VSS.n279 VSS.n278 0.0213125
R1849 VSS.n275 VSS.n122 0.0213125
R1850 VSS.n274 VSS.n124 0.0213125
R1851 VSS.n271 VSS.n270 0.0213125
R1852 VSS.n267 VSS.n126 0.0213125
R1853 VSS.n266 VSS.n133 0.0213125
R1854 VSS.n263 VSS.n262 0.0213125
R1855 VSS.n259 VSS.n135 0.0213125
R1856 VSS.n258 VSS.n257 0.0213125
R1857 VSS.n391 VSS.n67 0.021125
R1858 VSS.n136 VSS.n132 0.020375
R1859 VSS.n447 VSS.n40 0.020375
R1860 VSS.n350 VSS.n85 0.02
R1861 VSS.n351 VSS.n83 0.02
R1862 VSS.n355 VSS.n354 0.02
R1863 VSS.n358 VSS.n81 0.02
R1864 VSS.n359 VSS.n79 0.02
R1865 VSS.n363 VSS.n362 0.02
R1866 VSS.n366 VSS.n77 0.02
R1867 VSS.n367 VSS.n75 0.02
R1868 VSS.n374 VSS.n373 0.02
R1869 VSS.n377 VSS.n73 0.02
R1870 VSS.n378 VSS.n70 0.02
R1871 VSS.n386 VSS.n385 0.02
R1872 VSS.n389 VSS.n68 0.02
R1873 VSS.n390 VSS.n65 0.02
R1874 VSS.n397 VSS.n396 0.02
R1875 VSS.n400 VSS.n63 0.02
R1876 VSS.n401 VSS.n59 0.02
R1877 VSS.n408 VSS.n407 0.02
R1878 VSS.n411 VSS.n57 0.02
R1879 VSS.n412 VSS.n54 0.02
R1880 VSS.n420 VSS.n419 0.02
R1881 VSS.n423 VSS.n52 0.02
R1882 VSS.n424 VSS.n49 0.02
R1883 VSS.n429 VSS.n428 0.02
R1884 VSS.n432 VSS.n47 0.02
R1885 VSS.n433 VSS.n45 0.02
R1886 VSS.n438 VSS.n437 0.02
R1887 VSS.n441 VSS.n43 0.02
R1888 VSS.n442 VSS.n41 0.02
R1889 VSS.n508 VSS.n507 0.0190625
R1890 VSS VSS.n536 0.017375
R1891 VSS.n446 VSS.n38 0.014
R1892 VSS.n451 VSS.n450 0.014
R1893 VSS.n454 VSS.n37 0.014
R1894 VSS.n455 VSS.n35 0.014
R1895 VSS.n460 VSS.n458 0.014
R1896 VSS.n459 VSS.n32 0.014
R1897 VSS.n472 VSS.n471 0.014
R1898 VSS.n468 VSS.n33 0.014
R1899 VSS.n467 VSS.n465 0.014
R1900 VSS.n464 VSS.n28 0.014
R1901 VSS.n480 VSS.n479 0.014
R1902 VSS.n482 VSS.n26 0.014
R1903 VSS.n380 VSS.n379 0.012875
R1904 VSS.n405 VSS.n56 0.012125
R1905 VSS.n486 VSS.n22 0.0111875
R1906 VSS.n435 VSS.n434 0.0104375
R1907 VSS.n414 VSS.n413 0.009875
R1908 VSS.n371 VSS.n72 0.009125
R1909 VSS.n118 VSS.n114 0.00725
R1910 VSS.n260 VSS.n138 0.00725
R1911 VSS.n156 VSS.n152 0.00725
R1912 VSS.n163 VSS.n158 0.00725
R1913 VSS.n169 VSS.n165 0.00725
R1914 VSS.n484 VSS.n24 0.005
R1915 VSS.n489 VSS.n488 0.005
R1916 VSS.n492 VSS.n23 0.005
R1917 VSS.n493 VSS.n20 0.005
R1918 VSS.n501 VSS.n500 0.005
R1919 VSS.n504 VSS.n18 0.005
R1920 VSS.n505 VSS.n15 0.005
R1921 VSS.n510 VSS.n509 0.005
R1922 VSS.n513 VSS.n13 0.005
R1923 VSS.n514 VSS.n11 0.005
R1924 VSS.n427 VSS.n426 0.0036875
R1925 VSS.n477 VSS.n476 0.0036875
R1926 VSS.n506 VSS.n17 0.002375
R1927 VSS.n395 VSS.n394 0.000875
C0 oin outp 2.32216f
C1 outp nb 0.32997f
C2 inn tail 21.6972f
C3 outp outn 3.56533f
C4 outp oqp 0.13055f
C5 vcm inp 0.28752f
C6 inn oin 0
C7 VDD inp 0.24697f
C8 outp oip 0.18626f
C9 nb x2q_tail 6.97815f
C10 inn nb 0.84533f
C11 x2q_tail outn 8.15728f
C12 x2q_tail oqp 4.09819f
C13 oin x2i_tail 3.91883f
C14 inn outn 1.4769f
C15 vcm enb 2.73623f
C16 vcm VDD 0.8833f
C17 nb x2i_tail 4.58476f
C18 outn x2i_tail 5.79198f
C19 enb VDD 0.34841f
C20 nb oqn 3.7475f
C21 outn oqn 0.20838f
C22 oqn oqp 0.16891f
C23 oip x2i_tail 4.02866f
C24 vcm vt 0.07779f
C25 enb vt 0.39792f
C26 VDD vt 0.26026f
C27 outp inp 0.58906f
C28 tail nb 18.5174f
C29 tail outn 25.3551f
C30 oin nb 0.45181f
C31 vcm outp 0.37213f
C32 oin outn 0.34015f
C33 inn inp 7.71858f
C34 nb outn 4.11094f
C35 outp enb 0
C36 nb oqp 0.31636f
C37 outp VDD 5.31015f
C38 outn oqp 8.87469f
C39 oin oip 1.10126f
C40 x2i_tail inp 0
C41 vcm x2q_tail 0.00345f
C42 inn vcm 3.43572f
C43 nb oip 0.92946f
C44 outn oip 6.25655f
C45 vcm x2i_tail 0.00759f
C46 x2q_tail VDD 0.44326f
C47 inn VDD 0.30835f
C48 vcm oqn 0.43052f
C49 x2i_tail VDD 0.44747f
C50 tail inp 18.8461f
C51 enb oqn 0
C52 oqn VDD 4.14316f
C53 tail vcm 0.60498f
C54 nb inp 0.23145f
C55 outn inp 18.4613f
C56 oqn vt 0.13876f
C57 oin vcm 3.33651f
C58 tail enb 0
C59 tail VDD 0.284f
C60 outp x2q_tail 7.58093f
C61 inn outp 21.4308f
C62 vcm nb 6.11363f
C63 oip inp 0
C64 vcm outn 2.71659f
C65 vcm oqp 0.24483f
C66 oin VDD 3.94306f
C67 outp x2i_tail 5.04918f
C68 enb nb 2.13858f
C69 nb VDD 4.19008f
C70 enb outn 0
C71 enb oqp 7.429f
C72 outn VDD 0.98645f
C73 VDD oqp 2.06342f
C74 vcm oip 0.05223f
C75 outp oqn 4.85285f
C76 inn x2i_tail 0
C77 oip VDD 2.70945f
C78 nb vt 0.12457f
C79 oqp vt 0.0591f
C80 x2q_tail oqn 3.85225f
C81 tail outp 24.5656f
C82 oqp VSS 2.10089f
C83 oqn VSS 4.0945f
C84 enb VSS 1.24738f
C85 inn VSS 0.877558f
C86 inp VSS 1.18601f
C87 oip VSS 2.69416f
C88 nb VSS 9.37553f
C89 oin VSS 3.90022f
C90 VDD VSS 104.389f
C91 x2q_tail VSS 6.46619f
C92 vt VSS 0.67237f
C93 tail VSS 23.7494f
C94 vcm VSS 24.5663f
C95 x2i_tail VSS 6.56898f
C96 outn VSS 11.3948f
C97 outp VSS 12.358f
C98 VDD.n0 VSS 0.147384f
C99 VDD.n1 VSS 0.0352206f
C100 VDD.n2 VSS 0.192371f
C101 VDD.n3 VSS 0.0292307f
C102 VDD.n4 VSS 0.0584531f
C103 VDD.n5 VSS 0.0292307f
C104 VDD.n6 VSS 0.0584531f
C105 VDD.n7 VSS 0.0292307f
C106 VDD.n8 VSS 0.0584531f
C107 VDD.n9 VSS 0.0292307f
C108 VDD.n10 VSS 0.0584531f
C109 VDD.n11 VSS 0.0292307f
C110 VDD.n12 VSS 0.0584531f
C111 VDD.n13 VSS 0.0292307f
C112 VDD.n14 VSS 0.0584531f
C113 VDD.n15 VSS 0.0292307f
C114 VDD.n16 VSS 0.0584531f
C115 VDD.n17 VSS 0.0292307f
C116 VDD.n18 VSS 0.0584531f
C117 VDD.n19 VSS 0.0292307f
C118 VDD.n20 VSS 0.0584531f
C119 VDD.n21 VSS 0.0292307f
C120 VDD.n22 VSS 0.0584531f
C121 VDD.n23 VSS 0.0292307f
C122 VDD.n24 VSS 0.0584531f
C123 VDD.n25 VSS 0.0292307f
C124 VDD.n26 VSS 0.0584531f
C125 VDD.n27 VSS 0.0292307f
C126 VDD.n28 VSS 0.0584531f
C127 VDD.n29 VSS 0.0292307f
C128 VDD.n30 VSS 0.0584531f
C129 VDD.n31 VSS 0.0292307f
C130 VDD.n32 VSS 0.0584531f
C131 VDD.n33 VSS 0.0292307f
C132 VDD.n34 VSS 0.0584531f
C133 VDD.n35 VSS 0.0292307f
C134 VDD.n36 VSS 0.0584531f
C135 VDD.n37 VSS 0.0292307f
C136 VDD.n38 VSS 0.0584531f
C137 VDD.n39 VSS 0.0292307f
C138 VDD.n40 VSS 0.0584531f
C139 VDD.n41 VSS 0.0292307f
C140 VDD.n42 VSS -0.708386f
C141 VDD.n43 VSS 0.0292307f
C142 VDD.n44 VSS 0.0584531f
C143 VDD.n45 VSS 0.0292307f
C144 VDD.n46 VSS 0.0584531f
C145 VDD.n47 VSS 0.0292307f
C146 VDD.n48 VSS 0.0584531f
C147 VDD.n49 VSS 0.0292307f
C148 VDD.n50 VSS 0.0584531f
C149 VDD.n51 VSS 0.0292307f
C150 VDD.n52 VSS 0.0584531f
C151 VDD.n53 VSS 0.0292307f
C152 VDD.n54 VSS 0.0584531f
C153 VDD.n55 VSS 0.0292307f
C154 VDD.n56 VSS 0.0584531f
C155 VDD.n57 VSS 0.0292307f
C156 VDD.n58 VSS 0.0584531f
C157 VDD.n59 VSS 0.0292307f
C158 VDD.n60 VSS 0.0584531f
C159 VDD.n61 VSS 0.0292307f
C160 VDD.n62 VSS 0.0584531f
C161 VDD.n63 VSS 0.0292307f
C162 VDD.n64 VSS 0.0584531f
C163 VDD.n65 VSS 0.0292307f
C164 VDD.n66 VSS 0.0584531f
C165 VDD.n67 VSS 0.0292307f
C166 VDD.n68 VSS 0.0584531f
C167 VDD.n69 VSS 0.0292307f
C168 VDD.n70 VSS 0.0584531f
C169 VDD.n71 VSS 0.0292307f
C170 VDD.n72 VSS 0.0584531f
C171 VDD.n73 VSS 0.0292307f
C172 VDD.n74 VSS 0.0584531f
C173 VDD.n75 VSS 0.0292307f
C174 VDD.n76 VSS 0.0584531f
C175 VDD.n77 VSS 0.0292307f
C176 VDD.n78 VSS 0.0584531f
C177 VDD.n79 VSS 0.0292307f
C178 VDD.n80 VSS 0.0584531f
C179 VDD.n81 VSS 0.0292307f
C180 VDD.n82 VSS 0.202301f
C181 VDD.n83 VSS 0.0584531f
C182 VDD.n84 VSS 0.0360798f
C183 VDD.n85 VSS 0.0584531f
C184 VDD.n86 VSS 0.0292307f
C185 VDD.n87 VSS 0.0313127f
C186 VDD.n88 VSS 0.0584531f
C187 VDD.n89 VSS 0.0292307f
C188 VDD.n90 VSS 0.0584531f
C189 VDD.n91 VSS 0.0292307f
C190 VDD.n92 VSS 0.0584531f
C191 VDD.n93 VSS 0.0584531f
C192 VDD.n94 VSS 0.0292307f
C193 VDD.n95 VSS 0.0584531f
C194 VDD.n96 VSS 0.0292307f
C195 VDD.n97 VSS 0.0584531f
C196 VDD.n98 VSS 0.0292307f
C197 VDD.n99 VSS 0.0584531f
C198 VDD.n100 VSS 0.0292307f
C199 VDD.n101 VSS 0.0584531f
C200 VDD.n102 VSS 0.0292307f
C201 VDD.n103 VSS 0.0584531f
C202 VDD.n104 VSS 0.0292307f
C203 VDD.n105 VSS 0.0584531f
C204 VDD.n106 VSS 0.0292307f
C205 VDD.n107 VSS 0.0584531f
C206 VDD.n108 VSS 0.0292307f
C207 VDD.n109 VSS 0.0584531f
C208 VDD.n110 VSS 0.0292307f
C209 VDD.n111 VSS 0.0584531f
C210 VDD.n112 VSS 0.0292307f
C211 VDD.n113 VSS 0.0584531f
C212 VDD.n114 VSS 0.0292307f
C213 VDD.n115 VSS 0.0584531f
C214 VDD.n116 VSS 0.0292307f
C215 VDD.n117 VSS 0.0584531f
C216 VDD.n118 VSS 0.0292307f
C217 VDD.n119 VSS 0.100209f
C218 VDD.n120 VSS 0.0292307f
C219 VDD.n121 VSS 0.0507117f
C220 VDD.n122 VSS 0.0333203f
C221 VDD.t6 VSS 0.299834f
C222 VDD.n123 VSS 0.0584531f
C223 VDD.n124 VSS 0.0292307f
C224 VDD.n125 VSS 0.0584531f
C225 VDD.n126 VSS 0.0292307f
C226 VDD.n127 VSS 0.0584531f
C227 VDD.n128 VSS 0.0292307f
C228 VDD.n129 VSS 0.0584531f
C229 VDD.n130 VSS 0.0292307f
C230 VDD.n131 VSS 0.0584531f
C231 VDD.n132 VSS 0.0292307f
C232 VDD.n133 VSS 0.0584531f
C233 VDD.n134 VSS 0.0292307f
C234 VDD.t7 VSS 0.0159538f
C235 VDD.n135 VSS 0.0584531f
C236 VDD.n136 VSS 0.0292307f
C237 VDD.n137 VSS 0.0309822f
C238 VDD.n138 VSS 0.0584531f
C239 VDD.n139 VSS 0.0332047f
C240 VDD.n140 VSS 0.0292307f
C241 VDD.n141 VSS 0.0584531f
C242 VDD.n142 VSS 0.0292307f
C243 VDD.n143 VSS 0.0584531f
C244 VDD.n144 VSS 0.0292307f
C245 VDD.n145 VSS 0.0584531f
C246 VDD.n146 VSS 0.0292307f
C247 VDD.n147 VSS 0.0584531f
C248 VDD.n148 VSS 0.0292307f
C249 VDD.n149 VSS 0.0313127f
C250 VDD.n150 VSS 0.0584531f
C251 VDD.n151 VSS 0.0292307f
C252 VDD.n152 VSS 0.0584531f
C253 VDD.n153 VSS 0.0292307f
C254 VDD.n154 VSS 0.0584531f
C255 VDD.n155 VSS 0.0584531f
C256 VDD.n156 VSS 0.0292307f
C257 VDD.n157 VSS 0.0313127f
C258 VDD.t1 VSS 0.0842303f
C259 VDD.t4 VSS 0.0311061f
C260 VDD.n158 VSS 0.175558f
C261 VDD.n159 VSS 0.04782f
C262 VDD.n160 VSS 0.0175401f
C263 VDD.n161 VSS 0.0584531f
C264 VDD.n162 VSS 0.0584531f
C265 VDD.n163 VSS 0.0292307f
C266 VDD.n164 VSS 0.0292307f
C267 VDD.n165 VSS 0.100209f
C268 VDD.n166 VSS 0.0584531f
C269 VDD.n167 VSS 0.0292307f
C270 VDD.n168 VSS 0.0292307f
C271 VDD.n169 VSS 0.0584531f
C272 VDD.n170 VSS 0.0584531f
C273 VDD.n171 VSS 0.0292307f
C274 VDD.n172 VSS 0.0292307f
C275 VDD.n173 VSS 0.147806f
C276 VDD.n174 VSS 0.0336921f
C277 VDD.n175 VSS 0.0524632f
C278 VDD.n176 VSS 0.0567016f
C279 VDD.n177 VSS 0.0584531f
C280 VDD.n178 VSS 0.0584531f
C281 VDD.n179 VSS 0.0292307f
C282 VDD.n180 VSS 0.0292307f
C283 VDD.n181 VSS 0.100209f
C284 VDD.n182 VSS 0.0584531f
C285 VDD.n183 VSS 0.0292307f
C286 VDD.n184 VSS 0.0292307f
C287 VDD.n185 VSS 0.0584531f
C288 VDD.n186 VSS 0.0584531f
C289 VDD.n187 VSS 0.0292307f
C290 VDD.n188 VSS 0.0292307f
C291 VDD.n189 VSS 0.0584531f
C292 VDD.n190 VSS 0.0584531f
C293 VDD.n191 VSS 0.0292307f
C294 VDD.n192 VSS 0.0292307f
C295 VDD.n193 VSS 0.0584531f
C296 VDD.n194 VSS 0.0584531f
C297 VDD.n195 VSS 0.0292307f
C298 VDD.n196 VSS 0.0292307f
C299 VDD.n197 VSS 0.0584531f
C300 VDD.n198 VSS 0.138065f
C301 VDD.n199 VSS 0.0292307f
C302 VDD.n200 VSS 0.0292307f
C303 VDD.n201 VSS 0.0584531f
C304 VDD.n202 VSS 0.0584531f
C305 VDD.n203 VSS 0.0584531f
C306 VDD.n204 VSS 0.0531903f
C307 VDD.n205 VSS 0.0313127f
C308 VDD.n206 VSS 0.100209f
C309 VDD.n207 VSS 0.0292307f
C310 VDD.n208 VSS 0.0292307f
C311 VDD.n209 VSS 0.0309822f
C312 VDD.n210 VSS 0.049679f
C313 VDD.n211 VSS 0.0567016f
C314 VDD.n212 VSS 0.0292307f
C315 VDD.n213 VSS 0.0292307f
C316 VDD.n214 VSS 0.0584531f
C317 VDD.n215 VSS 0.0584531f
C318 VDD.n216 VSS 0.0292307f
C319 VDD.n217 VSS 0.0292307f
C320 VDD.n218 VSS 0.0584531f
C321 VDD.n219 VSS 0.0584531f
C322 VDD.n220 VSS 0.0292307f
C323 VDD.n221 VSS 0.0292307f
C324 VDD.n222 VSS 0.0584531f
C325 VDD.n223 VSS 0.0584531f
C326 VDD.n224 VSS 0.0292307f
C327 VDD.n225 VSS 0.0292307f
C328 VDD.n226 VSS 0.0584531f
C329 VDD.n227 VSS 0.0584531f
C330 VDD.n228 VSS 0.0292307f
C331 VDD.n229 VSS 0.0292307f
C332 VDD.n230 VSS 0.0584531f
C333 VDD.n231 VSS 0.140287f
C334 VDD.n232 VSS 0.0292307f
C335 VDD.n233 VSS 0.0292307f
C336 VDD.n234 VSS 0.0584531f
C337 VDD.n235 VSS 0.0369721f
C338 VDD.n236 VSS 0.0344853f
C339 VDD.n237 VSS 0.0508521f
C340 VDD.n238 VSS 0.0313127f
C341 VDD.n239 VSS 0.0292307f
C342 VDD.n240 VSS 0.0584531f
C343 VDD.n241 VSS 0.0584531f
C344 VDD.n242 VSS 0.0292307f
C345 VDD.n243 VSS 0.0292307f
C346 VDD.n244 VSS 0.0584531f
C347 VDD.n245 VSS 0.0584531f
C348 VDD.n246 VSS 0.0292307f
C349 VDD.n247 VSS 0.0292307f
C350 VDD.n248 VSS 0.0584531f
C351 VDD.n249 VSS 0.0584531f
C352 VDD.n250 VSS 0.0292307f
C353 VDD.n251 VSS 0.0292307f
C354 VDD.n252 VSS 0.0584531f
C355 VDD.n253 VSS 0.0584531f
C356 VDD.n254 VSS 0.0292307f
C357 VDD.n255 VSS 0.0292307f
C358 VDD.n256 VSS 0.0584531f
C359 VDD.n257 VSS 0.0584531f
C360 VDD.n258 VSS 0.0292307f
C361 VDD.n259 VSS 0.0292307f
C362 VDD.n260 VSS 0.0584531f
C363 VDD.n261 VSS 0.0584531f
C364 VDD.n262 VSS 0.0292307f
C365 VDD.n263 VSS 0.0292307f
C366 VDD.n264 VSS 0.0584531f
C367 VDD.n265 VSS 0.0584531f
C368 VDD.n266 VSS 0.0292307f
C369 VDD.n267 VSS 0.0292307f
C370 VDD.n268 VSS 0.0584531f
C371 VDD.n269 VSS 0.0584531f
C372 VDD.n270 VSS 0.0292307f
C373 VDD.n271 VSS 0.0292307f
C374 VDD.n272 VSS 0.0584531f
C375 VDD.n273 VSS 0.0584531f
C376 VDD.n274 VSS 0.0292307f
C377 VDD.n275 VSS 0.0292307f
C378 VDD.n276 VSS 0.0584531f
C379 VDD.n277 VSS 0.0584531f
C380 VDD.n278 VSS 0.0292307f
C381 VDD.n279 VSS 0.0292307f
C382 VDD.n280 VSS 0.0584531f
C383 VDD.n281 VSS 0.0584531f
C384 VDD.n282 VSS 0.0292307f
C385 VDD.n283 VSS 0.0292307f
C386 VDD.n284 VSS 0.0584531f
C387 VDD.n285 VSS 0.0584531f
C388 VDD.n286 VSS 0.0292307f
C389 VDD.n287 VSS 0.0292307f
C390 VDD.n288 VSS 0.0584531f
C391 VDD.n289 VSS 0.0584531f
C392 VDD.n290 VSS 0.0292307f
C393 VDD.n291 VSS 0.0292307f
C394 VDD.n292 VSS 0.0584531f
C395 VDD.n293 VSS 0.0584531f
C396 VDD.n294 VSS 0.0292307f
C397 VDD.n295 VSS 0.0292307f
C398 VDD.n296 VSS 0.0584531f
C399 VDD.n297 VSS 0.0584531f
C400 VDD.n298 VSS 0.0292307f
C401 VDD.n299 VSS 0.0292307f
C402 VDD.n300 VSS 0.12164f
C403 VDD.n301 VSS 0.0323867f
C404 VDD.n302 VSS 0.0287845f
C405 VDD.t5 VSS 0.0646743f
C406 VDD.t3 VSS 0.0551401f
C407 VDD.n303 VSS 0.082074f
C408 VDD.n304 VSS 0.0485884f
C409 VDD.n305 VSS 0.0175401f
C410 VDD.n306 VSS 0.0584531f
C411 VDD.n307 VSS 0.0584531f
C412 VDD.n308 VSS 0.0292307f
C413 VDD.n309 VSS 0.0292307f
C414 VDD.n310 VSS 0.100209f
C415 VDD.n311 VSS 0.0584531f
C416 VDD.n312 VSS 0.0292307f
C417 VDD.n313 VSS 0.0292307f
C418 VDD.n314 VSS 0.221461f
C419 VDD.n315 VSS 0.19727f
C420 VDD.n316 VSS 0.029809f
C421 VDD.n317 VSS 0.590876f
C422 VDD.n318 VSS 0.0584531f
C423 VDD.n319 VSS 0.0334112f
C424 VDD.n320 VSS 0.0292307f
C425 VDD.n321 VSS 0.222932f
C426 VDD.n322 VSS 0.0584531f
C427 VDD.n323 VSS 0.0292307f
C428 VDD.n324 VSS 0.0292307f
C429 VDD.n325 VSS 0.0584531f
C430 VDD.n326 VSS 0.0584531f
C431 VDD.n327 VSS 0.0292307f
C432 VDD.n328 VSS 0.0292307f
C433 VDD.n329 VSS 0.0584531f
C434 VDD.n330 VSS 0.0584531f
C435 VDD.n331 VSS 0.0292307f
C436 VDD.n332 VSS 0.0292307f
C437 VDD.n333 VSS 0.0584531f
C438 VDD.n334 VSS 0.0584531f
C439 VDD.n335 VSS 0.0292307f
C440 VDD.n336 VSS 0.0292307f
C441 VDD.n337 VSS 0.0584531f
C442 VDD.n338 VSS 0.0584531f
C443 VDD.n339 VSS 0.0292307f
C444 VDD.n340 VSS 0.0292307f
C445 VDD.n341 VSS 0.0584531f
C446 VDD.n342 VSS 0.0584531f
C447 VDD.n343 VSS 0.0292307f
C448 VDD.n344 VSS 0.0292307f
C449 VDD.n345 VSS 0.0584531f
C450 VDD.n346 VSS 0.0584531f
C451 VDD.n347 VSS 0.0292307f
C452 VDD.n348 VSS 0.0292307f
C453 VDD.n349 VSS 0.0584531f
C454 VDD.n350 VSS 0.0584531f
C455 VDD.n351 VSS 0.0292307f
C456 VDD.n352 VSS 0.0292307f
C457 VDD.n353 VSS 0.0584531f
C458 VDD.n354 VSS 0.0584531f
C459 VDD.n355 VSS 0.0292307f
C460 VDD.n356 VSS 0.0292307f
C461 VDD.n357 VSS 0.0584531f
C462 VDD.n358 VSS 0.0584531f
C463 VDD.n359 VSS 0.0292307f
C464 VDD.n360 VSS 0.0292307f
C465 VDD.n361 VSS 0.0584531f
C466 VDD.n362 VSS 0.0584531f
C467 VDD.n363 VSS 0.0292307f
C468 VDD.n364 VSS 0.0292307f
C469 VDD.n365 VSS 0.0584531f
C470 VDD.n366 VSS 0.0584531f
C471 VDD.n367 VSS 0.0292307f
C472 VDD.n368 VSS 0.0292307f
C473 VDD.n369 VSS 0.0584531f
C474 VDD.n370 VSS 0.0584531f
C475 VDD.n371 VSS 0.0292307f
C476 VDD.n372 VSS 0.0292307f
C477 VDD.n373 VSS 0.0584531f
C478 VDD.n374 VSS 0.0584531f
C479 VDD.n375 VSS 0.0292307f
C480 VDD.n376 VSS 0.0292307f
C481 VDD.n377 VSS 0.0584531f
C482 VDD.n378 VSS 0.0584531f
C483 VDD.n379 VSS 0.0292307f
C484 VDD.n380 VSS 0.0292307f
C485 VDD.n381 VSS 0.0584531f
C486 VDD.n382 VSS 0.0584531f
C487 VDD.n383 VSS 0.0292307f
C488 VDD.n384 VSS 0.0292307f
C489 VDD.n385 VSS 0.0584531f
C490 VDD.n386 VSS 0.0584531f
C491 VDD.n387 VSS 0.0292307f
C492 VDD.n388 VSS 0.0292307f
C493 VDD.n389 VSS 0.0584531f
C494 VDD.n390 VSS 0.0584531f
C495 VDD.n391 VSS 0.0292307f
C496 VDD.n392 VSS 0.0292307f
C497 VDD.n393 VSS 0.0584531f
C498 VDD.n394 VSS 0.0584531f
C499 VDD.n395 VSS 0.0292307f
C500 VDD.n396 VSS 0.0292307f
C501 VDD.n397 VSS 0.0584531f
C502 VDD.n398 VSS 0.0584531f
C503 VDD.n399 VSS 0.0292307f
C504 VDD.n400 VSS 0.0292307f
C505 VDD.n401 VSS -2.06843f
C506 VDD.n402 VSS 0.0584531f
C507 VDD.n403 VSS 0.0292307f
C508 VDD.n404 VSS 0.0292307f
C509 VDD.n405 VSS 0.0584531f
C510 VDD.n406 VSS 0.0584531f
C511 VDD.n407 VSS 0.0292307f
C512 VDD.n408 VSS 0.0292307f
C513 VDD.n409 VSS 0.0584531f
C514 VDD.n410 VSS 0.0584531f
C515 VDD.n411 VSS 0.0292307f
C516 VDD.n412 VSS 0.0292307f
C517 VDD.n413 VSS 0.0584531f
C518 VDD.n414 VSS 0.0584531f
C519 VDD.n415 VSS 0.0292307f
C520 VDD.n416 VSS 0.0292307f
C521 VDD.n417 VSS 0.0584531f
C522 VDD.n418 VSS 0.0584531f
C523 VDD.n419 VSS 0.0292307f
C524 VDD.n420 VSS 0.0292307f
C525 VDD.n421 VSS 0.0584531f
C526 VDD.n422 VSS 0.0584531f
C527 VDD.n423 VSS 0.0292307f
C528 VDD.n424 VSS 0.0292307f
C529 VDD.n425 VSS 0.0584531f
C530 VDD.n426 VSS 0.0584531f
C531 VDD.n427 VSS 0.0292307f
C532 VDD.n428 VSS 0.0292307f
C533 VDD.n429 VSS 0.0584531f
C534 VDD.n430 VSS 0.0584531f
C535 VDD.n431 VSS 0.0292307f
C536 VDD.n432 VSS 0.0292307f
C537 VDD.n433 VSS 0.0584531f
C538 VDD.n434 VSS 0.0584531f
C539 VDD.n435 VSS 0.0292307f
C540 VDD.n436 VSS 0.0292307f
C541 VDD.n437 VSS 0.0584531f
C542 VDD.n438 VSS 0.0584531f
C543 VDD.n439 VSS 0.0292307f
C544 VDD.n440 VSS 0.0292307f
C545 VDD.n441 VSS 0.0584531f
C546 VDD.n442 VSS 0.0584531f
C547 VDD.n443 VSS 0.0292307f
C548 VDD.n444 VSS 0.0292307f
C549 VDD.n445 VSS 0.0584531f
C550 VDD.n446 VSS 0.0584531f
C551 VDD.n447 VSS 0.0292307f
C552 VDD.n448 VSS 0.0292307f
C553 VDD.n449 VSS 0.0584531f
C554 VDD.n450 VSS 0.0584531f
C555 VDD.n451 VSS 0.0292307f
C556 VDD.n452 VSS 0.0292307f
C557 VDD.n453 VSS 0.0584531f
C558 VDD.n454 VSS 0.0584531f
C559 VDD.n455 VSS 0.0292307f
C560 VDD.n456 VSS 0.0292307f
C561 VDD.n457 VSS 0.0584531f
C562 VDD.n458 VSS 0.0584531f
C563 VDD.n459 VSS 0.0292307f
C564 VDD.n460 VSS 0.0292307f
C565 VDD.n461 VSS 0.0584531f
C566 VDD.n462 VSS 0.0584531f
C567 VDD.n463 VSS 0.0292307f
C568 VDD.n464 VSS 0.0292307f
C569 VDD.n465 VSS 0.0584531f
C570 VDD.n466 VSS 0.0584531f
C571 VDD.n467 VSS 0.0292307f
C572 VDD.n468 VSS 0.0292307f
C573 VDD.n469 VSS 0.0584531f
C574 VDD.n470 VSS 0.0584531f
C575 VDD.n471 VSS 0.0292307f
C576 VDD.n472 VSS 0.0292307f
C577 VDD.n473 VSS 0.0584531f
C578 VDD.n474 VSS 0.0584531f
C579 VDD.n475 VSS 0.0584531f
C580 VDD.n476 VSS 0.0292307f
C581 VDD.n477 VSS 0.0292307f
C582 VDD.n478 VSS 0.100209f
C583 VDD.n479 VSS 0.0313127f
C584 VDD.n480 VSS 0.0175401f
C585 VDD.t0 VSS 0.072895f
C586 VDD.t2 VSS 0.0247279f
C587 VDD.n481 VSS 0.158885f
C588 VDD.n482 VSS 0.0590067f
C589 VDD.n483 VSS 0.54941f
C590 VDD.n484 VSS 0.211307f
C591 VDD.n485 VSS 0.0262647f
C592 oin.t6 VSS 0.0985298f
C593 oin.t0 VSS 0.603511f
C594 oin.n0 VSS 0.223647f
C595 oin.t2 VSS 0.112982f
C596 oin.t1 VSS 0.112982f
C597 oin.n1 VSS 0.401985f
C598 oin.n2 VSS 0.111464f
C599 oin.t4 VSS 0.112982f
C600 oin.t3 VSS 0.112982f
C601 oin.n3 VSS 0.401985f
C602 oin.n4 VSS 0.111464f
C603 oin.t5 VSS 0.603511f
C604 oin.n5 VSS 0.468813f
C605 nb.t39 VSS 0.183974f
C606 nb.t38 VSS 0.183521f
C607 nb.n0 VSS 0.2425f
C608 nb.t37 VSS 0.183521f
C609 nb.n1 VSS 0.124436f
C610 nb.t36 VSS 0.183521f
C611 nb.n2 VSS 0.124436f
C612 nb.t35 VSS 0.183521f
C613 nb.n3 VSS 0.124436f
C614 nb.t34 VSS 0.183521f
C615 nb.n4 VSS 0.124436f
C616 nb.t33 VSS 0.183521f
C617 nb.n5 VSS 0.124436f
C618 nb.t32 VSS 0.183521f
C619 nb.n6 VSS 0.219258f
C620 nb.t8 VSS 0.186509f
C621 nb.t9 VSS 0.185928f
C622 nb.n7 VSS 0.311048f
C623 nb.t10 VSS 0.185928f
C624 nb.n8 VSS 0.158776f
C625 nb.t11 VSS 0.185928f
C626 nb.n9 VSS 0.158776f
C627 nb.t12 VSS 0.185928f
C628 nb.n10 VSS 0.158776f
C629 nb.t13 VSS 0.185928f
C630 nb.n11 VSS 0.158776f
C631 nb.t14 VSS 0.185928f
C632 nb.n12 VSS 0.158776f
C633 nb.t15 VSS 0.185928f
C634 nb.n13 VSS 0.158776f
C635 nb.t16 VSS 0.185928f
C636 nb.n14 VSS 0.158776f
C637 nb.t17 VSS 0.185928f
C638 nb.n15 VSS 0.158776f
C639 nb.t18 VSS 0.185928f
C640 nb.n16 VSS 0.158776f
C641 nb.t19 VSS 0.185928f
C642 nb.n17 VSS 0.158776f
C643 nb.t20 VSS 0.185928f
C644 nb.n18 VSS 0.158776f
C645 nb.t21 VSS 0.185928f
C646 nb.n19 VSS 0.158776f
C647 nb.t22 VSS 0.185928f
C648 nb.n20 VSS 0.158776f
C649 nb.t23 VSS 0.185928f
C650 nb.n21 VSS 0.158776f
C651 nb.t24 VSS 0.185928f
C652 nb.n22 VSS 0.150156f
C653 nb.t25 VSS 0.185928f
C654 nb.n23 VSS 0.154335f
C655 nb.t26 VSS 0.185928f
C656 nb.n24 VSS 0.158776f
C657 nb.t27 VSS 0.185928f
C658 nb.n25 VSS 0.158776f
C659 nb.t28 VSS 0.185928f
C660 nb.n26 VSS 0.158776f
C661 nb.t29 VSS 0.185928f
C662 nb.n27 VSS 0.158776f
C663 nb.t30 VSS 0.185928f
C664 nb.n28 VSS 0.158776f
C665 nb.t31 VSS 0.185928f
C666 nb.n29 VSS 0.323901f
C667 nb.n30 VSS 0.575608f
C668 nb.t7 VSS 0.18669f
C669 nb.t6 VSS 0.1861f
C670 nb.n31 VSS 0.319578f
C671 nb.t5 VSS 0.1861f
C672 nb.n32 VSS 0.164959f
C673 nb.t4 VSS 0.1861f
C674 nb.n33 VSS 0.164959f
C675 nb.t3 VSS 0.1861f
C676 nb.n34 VSS 0.164959f
C677 nb.t2 VSS 0.1861f
C678 nb.n35 VSS 0.164959f
C679 nb.t1 VSS 0.1861f
C680 nb.n36 VSS 0.164959f
C681 nb.t0 VSS 0.1861f
C682 nb.n37 VSS 0.423652f
C683 nb.n38 VSS 0.393909f
C684 oip.t2 VSS 0.103607f
C685 oip.t1 VSS 0.103607f
C686 oip.n0 VSS 0.419113f
C687 oip.t4 VSS 0.103607f
C688 oip.t3 VSS 0.103607f
C689 oip.n1 VSS 0.407553f
C690 oip.n2 VSS 0.184761f
C691 oip.t6 VSS 0.103607f
C692 oip.t5 VSS 0.103607f
C693 oip.n3 VSS 0.407553f
C694 oip.n4 VSS 0.214459f
C695 oip.t0 VSS 0.109173f
C696 oip.n5 VSS 0.450617f
C697 inp.t1 VSS 0.112425f
C698 inp.t2 VSS 0.111577f
C699 inp.n0 VSS 0.296858f
C700 inp.t3 VSS 0.111577f
C701 inp.n1 VSS 0.153176f
C702 inp.t4 VSS 0.111577f
C703 inp.n2 VSS 0.153176f
C704 inp.t5 VSS 0.111577f
C705 inp.n3 VSS 0.153176f
C706 inp.t6 VSS 0.111577f
C707 inp.n4 VSS 0.153176f
C708 inp.t7 VSS 0.111577f
C709 inp.n5 VSS 0.153176f
C710 inp.t8 VSS 0.111577f
C711 inp.n6 VSS 0.153176f
C712 inp.t9 VSS 0.111577f
C713 inp.n7 VSS 0.153176f
C714 inp.t10 VSS 0.111577f
C715 inp.n8 VSS 0.153176f
C716 inp.t11 VSS 0.111577f
C717 inp.n9 VSS 0.153176f
C718 inp.t12 VSS 0.111577f
C719 inp.n10 VSS 0.153176f
C720 inp.t13 VSS 0.111577f
C721 inp.n11 VSS 0.153176f
C722 inp.t14 VSS 0.111577f
C723 inp.n12 VSS 0.153176f
C724 inp.t15 VSS 0.111577f
C725 inp.n13 VSS 0.144146f
C726 inp.t16 VSS 0.111577f
C727 inp.n14 VSS 0.125319f
C728 inp.t17 VSS 0.111577f
C729 inp.n15 VSS 0.153176f
C730 inp.t18 VSS 0.111577f
C731 inp.n16 VSS 0.153176f
C732 inp.t19 VSS 0.111577f
C733 inp.n17 VSS 0.153176f
C734 inp.t20 VSS 0.111577f
C735 inp.n18 VSS 0.153176f
C736 inp.t21 VSS 0.111577f
C737 inp.n19 VSS 0.153176f
C738 inp.t22 VSS 0.111577f
C739 inp.n20 VSS 0.153176f
C740 inp.t23 VSS 0.111577f
C741 inp.n21 VSS 0.153176f
C742 inp.t24 VSS 0.111577f
C743 inp.n22 VSS 0.296687f
C744 inp.t0 VSS 0.0283388f
C745 inp.n23 VSS 0.178243f
C746 inn.t1 VSS 0.0999852f
C747 inn.t2 VSS 0.0997538f
C748 inn.n0 VSS 0.265247f
C749 inn.t3 VSS 0.0997538f
C750 inn.n1 VSS 0.147532f
C751 inn.t4 VSS 0.0997538f
C752 inn.n2 VSS 0.147532f
C753 inn.t5 VSS 0.0997538f
C754 inn.n3 VSS 0.147532f
C755 inn.t6 VSS 0.0997538f
C756 inn.n4 VSS 0.147532f
C757 inn.t7 VSS 0.0997538f
C758 inn.n5 VSS 0.147532f
C759 inn.t8 VSS 0.0997538f
C760 inn.n6 VSS 0.147532f
C761 inn.t9 VSS 0.0997538f
C762 inn.n7 VSS 0.147532f
C763 inn.t10 VSS 0.0997538f
C764 inn.n8 VSS 0.147532f
C765 inn.t11 VSS 0.0997538f
C766 inn.n9 VSS 0.147532f
C767 inn.t12 VSS 0.0997538f
C768 inn.n10 VSS 0.147532f
C769 inn.t13 VSS 0.0997538f
C770 inn.n11 VSS 0.147532f
C771 inn.t14 VSS 0.0997538f
C772 inn.n12 VSS 0.147532f
C773 inn.t15 VSS 0.0997538f
C774 inn.n13 VSS 0.147532f
C775 inn.t16 VSS 0.0997538f
C776 inn.n14 VSS 0.123078f
C777 inn.t17 VSS 0.0997538f
C778 inn.n15 VSS 0.139152f
C779 inn.t18 VSS 0.0997538f
C780 inn.n16 VSS 0.147532f
C781 inn.t19 VSS 0.0997538f
C782 inn.n17 VSS 0.147532f
C783 inn.t20 VSS 0.0997538f
C784 inn.n18 VSS 0.147532f
C785 inn.t21 VSS 0.0997538f
C786 inn.n19 VSS 0.147532f
C787 inn.t22 VSS 0.0997538f
C788 inn.n20 VSS 0.147532f
C789 inn.t23 VSS 0.0997538f
C790 inn.n21 VSS 0.147532f
C791 inn.t24 VSS 0.0997538f
C792 inn.n22 VSS 0.201055f
C793 inn.t0 VSS 0.0297603f
C794 inn.n23 VSS 0.176691f
C795 enb.t0 VSS 0.0737876f
C796 oqn.t6 VSS 0.130856f
C797 oqn.t0 VSS 0.669327f
C798 oqn.n0 VSS 0.261223f
C799 oqn.t2 VSS 0.119545f
C800 oqn.t1 VSS 0.119545f
C801 oqn.n1 VSS 0.455497f
C802 oqn.n2 VSS 0.128752f
C803 oqn.t4 VSS 0.119545f
C804 oqn.t3 VSS 0.119545f
C805 oqn.n3 VSS 0.455497f
C806 oqn.n4 VSS 0.128752f
C807 oqn.t5 VSS 0.669327f
C808 oqn.n5 VSS 0.506253f
C809 oqp.t2 VSS 0.102709f
C810 oqp.t1 VSS 0.102709f
C811 oqp.n0 VSS 0.440501f
C812 oqp.t4 VSS 0.102709f
C813 oqp.t3 VSS 0.102709f
C814 oqp.n1 VSS 0.428228f
C815 oqp.n2 VSS 0.204358f
C816 oqp.t6 VSS 0.102709f
C817 oqp.t5 VSS 0.102709f
C818 oqp.n3 VSS 0.428228f
C819 oqp.n4 VSS 0.242498f
C820 oqp.t0 VSS 0.128998f
C821 oqp.n5 VSS 0.46115f
.ends
