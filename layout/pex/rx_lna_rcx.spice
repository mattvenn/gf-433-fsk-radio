* rx_lna: magic R+C extraction of layout/rx_lna.gds (layout/gen/pex.sh)
* rcfix.py: split-net C to VSS scaled by (S - K) / S on 9 nets (coupling double count removed)
* extracted 2026-11-16T12:08:56+01:00 with magic 8.3.642, mode rc, from rx_lna.gds
.subckt rx_lna VDD VSS inp inn oip oin oqp oqn nb enb
X0 inp.t0 vcm VSS.t24 ppolyf_u_1k r_width=1u r_length=20u
X1 oqp.t4 outn x2q_tail VSS.t37 nfet_03v3 ad=5p pd=11u as=5p ps=11u w=10u l=0.28u
X2 x2q_tail nb.t3 VSS.t164 VSS.t163 nfet_03v3 ad=5p pd=11u as=5p ps=11u w=10u l=0.5u
X3 outp inn.t12 tail VSS.t12 nfet_03v3 ad=5p pd=11u as=5p ps=11u w=10u l=0.28u
X4 tail inn.t15 outp VSS.t9 nfet_03v3 ad=5p pd=11u as=5p ps=11u w=10u l=0.28u
X5 tail inp.t2 outn VSS.t89 nfet_03v3 ad=5p pd=11u as=5p ps=11u w=10u l=0.28u
X6 outn inp.t13 tail VSS.t78 nfet_03v3 ad=5p pd=11u as=5p ps=11u w=10u l=0.28u
X7 VSS.t142 nb.t14 tail VSS.t141 nfet_03v3 ad=2.8p pd=10.56u as=5p ps=11u w=10u l=0.5u
X8 x2q_tail nb.t5 VSS.t160 VSS.t159 nfet_03v3 ad=5p pd=11u as=5p ps=11u w=10u l=0.5u
X9 VSS.t170 nb.t0 x2q_tail VSS.t169 nfet_03v3 ad=10p pd=22u as=5p ps=11u w=10u l=0.5u
X10 VSS.t138 nb.t16 tail VSS.t137 nfet_03v3 ad=2.8p pd=10.56u as=5p ps=11u w=10u l=0.5u
X11 outn inp.t11 tail VSS.t80 nfet_03v3 ad=5p pd=11u as=5p ps=11u w=10u l=0.28u
X12 tail inp.t8 outn VSS.t83 nfet_03v3 ad=5p pd=11u as=5p ps=11u w=10u l=0.28u
X13 VSS.t53 vcm VSS.t53 VSS.t52 nfet_03v3 ad=4.4235p pd=20.56u as=0 ps=0 w=9.83u l=10u
X14 VSS.t166 nb.t2 x2q_tail VSS.t165 nfet_03v3 ad=5p pd=11u as=5p ps=11u w=10u l=0.5u
X15 tail inp.t20 outn VSS.t72 nfet_03v3 ad=5p pd=11u as=5p ps=11u w=10u l=0.28u
X16 tail inn.t9 outp VSS.t15 nfet_03v3 ad=5p pd=11u as=5p ps=11u w=10u l=0.28u
X17 tail inn.t21 outp VSS.t3 nfet_03v3 ad=5p pd=11u as=5p ps=11u w=10u l=0.28u
X18 VSS.t122 nb.t24 tail VSS.t121 nfet_03v3 ad=2.8p pd=10.56u as=5p ps=11u w=10u l=0.5u
X19 x2i_tail outp oin.t4 VSS.t43 nfet_03v3 ad=5p pd=11u as=5p ps=11u w=10u l=0.28u
X20 tail nb.t21 VSS.t128 VSS.t127 nfet_03v3 ad=5p pd=11u as=2.8p ps=10.56u w=10u l=0.5u
X21 VSS.t118 nb.t26 tail VSS.t117 nfet_03v3 ad=2.8p pd=10.56u as=5p ps=11u w=10u l=0.5u
X22 outp inn.t16 tail VSS.t8 nfet_03v3 ad=5p pd=11u as=5p ps=11u w=10u l=0.28u
X23 x2q_tail outn oqp.t5 VSS.t38 nfet_03v3 ad=5p pd=11u as=5p ps=11u w=10u l=0.28u
X24 tail nb.t23 VSS.t124 VSS.t123 nfet_03v3 ad=5p pd=11u as=2.8p ps=10.56u w=10u l=0.5u
X25 x2i_tail nb.t35 VSS.t104 VSS.t103 nfet_03v3 ad=5p pd=11u as=2.8p ps=10.56u w=10u l=0.5u
X26 outn inp.t17 tail VSS.t75 nfet_03v3 ad=5p pd=11u as=5p ps=11u w=10u l=0.28u
X27 VSS.t55 vcm VSS.t55 VSS.t54 nfet_03v3 ad=2.7524p pd=10.39u as=0 ps=0 w=9.83u l=10u
X28 VSS.t102 nb.t36 x2i_tail VSS.t101 nfet_03v3 ad=2.8p pd=10.56u as=5p ps=11u w=10u l=0.5u
X29 x2q_tail outn oqp.t3 VSS.t36 nfet_03v3 ad=5p pd=11u as=5p ps=11u w=10u l=0.28u
X30 outp inn.t4 tail VSS.t20 nfet_03v3 ad=5p pd=11u as=5p ps=11u w=10u l=0.28u
X31 VSS.t57 vcm VSS.t57 VSS.t56 nfet_03v3 ad=2.7524p pd=10.39u as=0 ps=0 w=9.83u l=10u
X32 outp VDD.t4 VSS.t66 ppolyf_u r_width=4u r_length=9.14u
X33 oip.t0 outn x2i_tail VSS.t27 nfet_03v3 ad=5p pd=11u as=5p ps=11u w=10u l=0.28u
X34 oin.t3 outp x2i_tail VSS.t42 nfet_03v3 ad=5p pd=11u as=5p ps=11u w=10u l=0.28u
X35 VSS.t110 nb.t32 x2i_tail VSS.t109 nfet_03v3 ad=4.5p pd=20.9u as=5p ps=11u w=10u l=0.5u
X36 outn inp.t5 tail VSS.t86 nfet_03v3 ad=5p pd=11u as=5p ps=11u w=10u l=0.28u
X37 oqn.t6 VDD.t2 VSS.t64 ppolyf_u r_width=2u r_length=9.14u
X38 tail nb.t9 VSS.t152 VSS.t151 nfet_03v3 ad=5p pd=11u as=2.8p ps=10.56u w=10u l=0.5u
X39 outn inp.t3 tail VSS.t88 nfet_03v3 ad=5p pd=11u as=5p ps=11u w=10u l=0.28u
X40 tail inn.t13 outp VSS.t11 nfet_03v3 ad=5p pd=11u as=5p ps=11u w=10u l=0.28u
X41 outp inn.t22 tail VSS.t2 nfet_03v3 ad=5p pd=11u as=5p ps=11u w=10u l=0.28u
X42 outp inn.t10 tail VSS.t14 nfet_03v3 ad=5p pd=11u as=5p ps=11u w=10u l=0.28u
X43 x2q_tail outn oqp.t1 VSS.t34 nfet_03v3 ad=5p pd=11u as=5p ps=11u w=10u l=0.28u
X44 tail nb.t11 VSS.t148 VSS.t147 nfet_03v3 ad=5p pd=11u as=2.8p ps=10.56u w=10u l=0.5u
X45 outn inp.t23 tail VSS.t69 nfet_03v3 ad=5p pd=11u as=5p ps=11u w=10u l=0.28u
X46 tail inn.t1 outp VSS.t23 nfet_03v3 ad=5p pd=11u as=5p ps=11u w=10u l=0.28u
X47 vt enb.t0 VDD.t7 VDD.t6 pfet_03v3 ad=2p pd=6u as=2p ps=6u w=2u l=0.28u
X48 VSS.t146 nb.t12 tail VSS.t145 nfet_03v3 ad=2.8p pd=10.56u as=5p ps=11u w=10u l=0.5u
X49 outp inn.t24 tail VSS.t0 nfet_03v3 ad=5p pd=11u as=5p ps=11u w=10u l=0.28u
X50 vt vcm VSS.t26 ppolyf_u_1k r_width=1u r_length=40u
X51 tail inp.t6 outn VSS.t85 nfet_03v3 ad=5p pd=11u as=5p ps=11u w=10u l=0.28u
X52 tail inp.t18 outn VSS.t74 nfet_03v3 ad=5p pd=11u as=5p ps=11u w=10u l=0.28u
X53 x2i_tail outn oip.t1 VSS.t28 nfet_03v3 ad=5p pd=11u as=5p ps=11u w=10u l=0.28u
X54 tail inn.t7 outp VSS.t17 nfet_03v3 ad=5p pd=11u as=5p ps=11u w=10u l=0.28u
X55 tail inn.t19 outp VSS.t5 nfet_03v3 ad=5p pd=11u as=5p ps=11u w=10u l=0.28u
X56 oqn.t3 outp x2q_tail VSS.t48 nfet_03v3 ad=5p pd=11u as=5p ps=11u w=10u l=0.28u
X57 x2i_tail outn oip.t3 VSS.t30 nfet_03v3 ad=5p pd=11u as=5p ps=11u w=10u l=0.28u
X58 tail nb.t17 VSS.t136 VSS.t135 nfet_03v3 ad=5p pd=11u as=2.8p ps=10.56u w=10u l=0.5u
X59 VSS.t126 nb.t22 tail VSS.t125 nfet_03v3 ad=2.8p pd=10.56u as=5p ps=11u w=10u l=0.5u
X60 oqn.t1 outp x2q_tail VSS.t46 nfet_03v3 ad=5p pd=11u as=5p ps=11u w=10u l=0.28u
X61 x2i_tail outp oin.t0 VSS.t39 nfet_03v3 ad=5p pd=11u as=10p ps=22u w=10u l=0.28u
X62 outn VDD.t1 VSS.t3 ppolyf_u r_width=4u r_length=9.14u
X63 tail nb.t19 VSS.t132 VSS.t131 nfet_03v3 ad=5p pd=11u as=2.8p ps=10.56u w=10u l=0.5u
X64 tail inp.t4 outn VSS.t87 nfet_03v3 ad=5p pd=11u as=5p ps=11u w=10u l=0.28u
X65 tail inn.t5 outp VSS.t19 nfet_03v3 ad=5p pd=11u as=5p ps=11u w=10u l=0.28u
X66 tail inp.t12 outn VSS.t79 nfet_03v3 ad=5p pd=11u as=5p ps=11u w=10u l=0.28u
X67 oip.t2 outn x2i_tail VSS.t29 nfet_03v3 ad=5p pd=11u as=5p ps=11u w=10u l=0.28u
X68 tail inn.t23 outp VSS.t1 nfet_03v3 ad=5p pd=11u as=5p ps=11u w=10u l=0.28u
X69 outn inp.t1 tail VSS.t90 nfet_03v3 ad=10p pd=22u as=5p ps=11u w=10u l=0.28u
X70 VSS.t150 nb.t10 tail VSS.t149 nfet_03v3 ad=2.8p pd=10.56u as=5p ps=11u w=10u l=0.5u
X71 tail nb.t29 VSS.t112 VSS.t111 nfet_03v3 ad=5p pd=11u as=2.8p ps=10.56u w=10u l=0.5u
X72 outp inn.t8 tail VSS.t16 nfet_03v3 ad=5p pd=11u as=5p ps=11u w=10u l=0.28u
X73 vcm VSS.t63 VSS.t62 ppolyf_u_1k r_width=1u r_length=30u
X74 outp inn.t20 tail VSS.t4 nfet_03v3 ad=5p pd=11u as=5p ps=11u w=10u l=0.28u
X75 x2i_tail nb.t37 VSS.t100 VSS.t99 nfet_03v3 ad=5p pd=11u as=2.8p ps=10.56u w=10u l=0.5u
X76 oip.t6 VDD.t5 VSS.t67 ppolyf_u r_width=2u r_length=9.14u
X77 oqn.t5 outp x2q_tail VSS.t50 nfet_03v3 ad=10p pd=22u as=5p ps=11u w=10u l=0.28u
X78 outp inn.t2 tail VSS.t22 nfet_03v3 ad=5p pd=11u as=5p ps=11u w=10u l=0.28u
X79 tail nb.t31 VSS.t92 VSS.t91 nfet_03v3 ad=5p pd=11u as=4.5p ps=20.9u w=10u l=0.5u
X80 outn inp.t9 tail VSS.t82 nfet_03v3 ad=5p pd=11u as=5p ps=11u w=10u l=0.28u
X81 outn inp.t21 tail VSS.t71 nfet_03v3 ad=5p pd=11u as=5p ps=11u w=10u l=0.28u
X82 oqp.t6 VDD.t3 VSS.t65 ppolyf_u r_width=2u r_length=9.14u
X83 VSS.t98 nb.t38 x2i_tail VSS.t97 nfet_03v3 ad=2.8p pd=10.56u as=5p ps=11u w=10u l=0.5u
X84 oin.t5 outp x2i_tail VSS.t44 nfet_03v3 ad=10p pd=22u as=5p ps=11u w=10u l=0.28u
X85 x2i_tail nb.t33 VSS.t108 VSS.t107 nfet_03v3 ad=5p pd=11u as=2.8p ps=10.56u w=10u l=0.5u
X86 x2q_tail outp oqn.t0 VSS.t45 nfet_03v3 ad=5p pd=11u as=10p ps=22u w=10u l=0.28u
X87 inn.t0 vcm VSS.t25 ppolyf_u_1k r_width=1u r_length=20u
X88 oin.t6 VDD.t0 VSS.t51 ppolyf_u r_width=2u r_length=9.14u
X89 outp inn.t14 tail VSS.t10 nfet_03v3 ad=5p pd=11u as=5p ps=11u w=10u l=0.28u
X90 x2i_tail outn oip.t5 VSS.t32 nfet_03v3 ad=5p pd=11u as=5p ps=11u w=10u l=0.28u
X91 tail nb.t13 VSS.t144 VSS.t143 nfet_03v3 ad=5p pd=11u as=2.8p ps=10.56u w=10u l=0.5u
X92 outn inp.t15 tail VSS.t76 nfet_03v3 ad=5p pd=11u as=5p ps=11u w=10u l=0.28u
X93 VSS.t134 nb.t18 tail VSS.t133 nfet_03v3 ad=2.8p pd=10.56u as=5p ps=11u w=10u l=0.5u
X94 tail nb.t15 VSS.t140 VSS.t139 nfet_03v3 ad=5p pd=11u as=2.8p ps=10.56u w=10u l=0.5u
X95 VSS.t130 nb.t20 tail VSS.t129 nfet_03v3 ad=2.8p pd=10.56u as=5p ps=11u w=10u l=0.5u
X96 tail inn.t3 outp VSS.t21 nfet_03v3 ad=5p pd=11u as=5p ps=11u w=10u l=0.28u
X97 tail inp.t10 outn VSS.t81 nfet_03v3 ad=5p pd=11u as=5p ps=11u w=10u l=0.28u
X98 tail inp.t22 outn VSS.t70 nfet_03v3 ad=5p pd=11u as=5p ps=11u w=10u l=0.28u
X99 oqp.t2 outn x2q_tail VSS.t35 nfet_03v3 ad=5p pd=11u as=5p ps=11u w=10u l=0.28u
X100 x2q_tail outp oqn.t4 VSS.t49 nfet_03v3 ad=5p pd=11u as=5p ps=11u w=10u l=0.28u
X101 tail inn.t11 outp VSS.t13 nfet_03v3 ad=5p pd=11u as=5p ps=11u w=10u l=0.28u
X102 x2q_tail nb.t7 VSS.t156 VSS.t155 nfet_03v3 ad=5p pd=11u as=10p ps=22u w=10u l=0.5u
X103 VSS.t114 nb.t28 tail VSS.t113 nfet_03v3 ad=2.8p pd=10.56u as=5p ps=11u w=10u l=0.5u
X104 x2i_tail outp oin.t2 VSS.t41 nfet_03v3 ad=5p pd=11u as=5p ps=11u w=10u l=0.28u
X105 oqp.t0 outn x2q_tail VSS.t33 nfet_03v3 ad=5p pd=11u as=5p ps=11u w=10u l=0.28u
X106 VSS.t61 vcm VSS.t61 VSS.t60 nfet_03v3 ad=4.915p pd=10.83u as=0 ps=0 w=9.83u l=10u
X107 tail nb.t25 VSS.t120 VSS.t119 nfet_03v3 ad=5p pd=11u as=2.8p ps=10.56u w=10u l=0.5u
X108 x2q_tail outp oqn.t2 VSS.t47 nfet_03v3 ad=5p pd=11u as=5p ps=11u w=10u l=0.28u
X109 outp inn.t6 tail VSS.t18 nfet_03v3 ad=5p pd=11u as=5p ps=11u w=10u l=0.28u
X110 tail inp.t24 outn VSS.t68 nfet_03v3 ad=5p pd=11u as=10p ps=22u w=10u l=0.28u
X111 VSS.t94 nb.t30 tail VSS.t93 nfet_03v3 ad=2.8p pd=10.56u as=5p ps=11u w=10u l=0.5u
X112 outp inn.t18 tail VSS.t6 nfet_03v3 ad=5p pd=11u as=5p ps=11u w=10u l=0.28u
X113 x2i_tail nb.t39 VSS.t96 VSS.t95 nfet_03v3 ad=5p pd=11u as=4.5p ps=20.9u w=10u l=0.5u
X114 VSS.t162 nb.t4 x2q_tail VSS.t161 nfet_03v3 ad=5p pd=11u as=5p ps=11u w=10u l=0.5u
X115 VSS.t154 nb.t8 tail VSS.t153 nfet_03v3 ad=4.5p pd=20.9u as=5p ps=11u w=10u l=0.5u
X116 tail nb.t27 VSS.t116 VSS.t115 nfet_03v3 ad=5p pd=11u as=2.8p ps=10.56u w=10u l=0.5u
X117 outn inp.t7 tail VSS.t84 nfet_03v3 ad=5p pd=11u as=5p ps=11u w=10u l=0.28u
X118 outn inp.t19 tail VSS.t73 nfet_03v3 ad=5p pd=11u as=5p ps=11u w=10u l=0.28u
X119 VSS.t106 nb.t34 x2i_tail VSS.t105 nfet_03v3 ad=2.8p pd=10.56u as=5p ps=11u w=10u l=0.5u
X120 oip.t4 outn x2i_tail VSS.t31 nfet_03v3 ad=5p pd=11u as=5p ps=11u w=10u l=0.28u
X121 tail inp.t16 outn VSS.t66 nfet_03v3 ad=5p pd=11u as=5p ps=11u w=10u l=0.28u
X122 VSS.t158 nb.t6 x2q_tail VSS.t157 nfet_03v3 ad=5p pd=11u as=5p ps=11u w=10u l=0.5u
X123 VSS.t59 vcm VSS.t59 VSS.t58 nfet_03v3 ad=9.83p pd=21.66u as=0 ps=0 w=9.83u l=10u
X124 x2q_tail nb.t1 VSS.t168 VSS.t167 nfet_03v3 ad=5p pd=11u as=5p ps=11u w=10u l=0.5u
X125 oin.t1 outp x2i_tail VSS.t40 nfet_03v3 ad=5p pd=11u as=5p ps=11u w=10u l=0.28u
X126 tail inn.t17 outp VSS.t7 nfet_03v3 ad=5p pd=11u as=5p ps=11u w=10u l=0.28u
X127 tail inp.t14 outn VSS.t77 nfet_03v3 ad=5p pd=11u as=5p ps=11u w=10u l=0.28u
R0 oqp.n5 oqp.t6 9.24997
R1 oqp.n2 oqp.n0 8.87418
R2 oqp.n2 oqp.n1 7.66155
R3 oqp.n4 oqp.n3 7.66155
R4 oqp.n5 oqp.n4 4.72313
R5 oqp oqp.n5 3.12208
R6 oqp.n4 oqp.n2 1.21313
R7 oqp.n0 oqp.t1 0.3155
R8 oqp.n0 oqp.t0 0.3155
R9 oqp.n1 oqp.t3 0.3155
R10 oqp.n1 oqp.t2 0.3155
R11 oqp.n3 oqp.t5 0.3155
R12 oqp.n3 oqp.t4 0.3155
R13 oqn.n0 oqn.t6 10.0031
R14 oqn.n0 oqn.t0 7.17129
R15 oqn.n5 oqn.t5 7.17129
R16 oqn.n2 oqn.n1 6.85629
R17 oqn.n4 oqn.n3 6.85629
R18 oqn oqn.n5 6.15603
R19 oqn.n5 oqn.n4 1.21313
R20 oqn.n4 oqn.n2 1.21313
R21 oqn.n2 oqn.n0 1.21313
R22 oqn.n1 oqn.t2 0.3155
R23 oqn.n1 oqn.t1 0.3155
R24 oqn.n3 oqn.t4 0.3155
R25 oqn.n3 oqn.t3 0.3155
R26 enb enb.t0 55.3171
R27 inn.n0 inn.t1 153.897
R28 inn.n24 inn.t24 153.593
R29 inn.n23 inn.t23 153.593
R30 inn.n22 inn.t22 153.593
R31 inn.n21 inn.t21 153.593
R32 inn.n20 inn.t20 153.593
R33 inn.n19 inn.t19 153.593
R34 inn.n18 inn.t18 153.593
R35 inn.n17 inn.t17 153.593
R36 inn.n16 inn.t16 153.593
R37 inn.n15 inn.t15 153.593
R38 inn.n10 inn.t12 153.593
R39 inn.n9 inn.t11 153.593
R40 inn.n8 inn.t10 153.593
R41 inn.n7 inn.t9 153.593
R42 inn.n6 inn.t8 153.593
R43 inn.n5 inn.t7 153.593
R44 inn.n4 inn.t6 153.593
R45 inn.n3 inn.t5 153.593
R46 inn.n2 inn.t4 153.593
R47 inn.n1 inn.t3 153.593
R48 inn.n0 inn.t2 153.593
R49 inn.n11 inn.t13 149.093
R50 inn.n13 inn.t14 149.083
R51 inn.n13 inn.t0 8.23499
R52 inn.n14 inn.n13 4.5005
R53 inn.n12 inn.n11 4.5005
R54 inn.n1 inn.n0 0.909974
R55 inn.n3 inn.n2 0.909974
R56 inn.n5 inn.n4 0.909974
R57 inn.n7 inn.n6 0.909974
R58 inn.n9 inn.n8 0.909974
R59 inn.n17 inn.n16 0.909974
R60 inn.n19 inn.n18 0.909974
R61 inn.n21 inn.n20 0.909974
R62 inn.n23 inn.n22 0.909974
R63 inn inn.n24 0.9005
R64 inn.n15 inn.n14 0.88629
R65 inn inn.n10 0.881553
R66 inn.n14 inn.n12 0.327342
R67 inn.n2 inn.n1 0.303658
R68 inn.n4 inn.n3 0.303658
R69 inn.n6 inn.n5 0.303658
R70 inn.n8 inn.n7 0.303658
R71 inn.n10 inn.n9 0.303658
R72 inn.n16 inn.n15 0.303658
R73 inn.n18 inn.n17 0.303658
R74 inn.n20 inn.n19 0.303658
R75 inn.n22 inn.n21 0.303658
R76 inn.n24 inn.n23 0.303658
R77 inn.n12 inn 0.0289211
R78 inp.n0 inp.t1 154.825
R79 inp.n22 inp.t24 153.916
R80 inp.n21 inp.t23 153.916
R81 inp.n20 inp.t22 153.916
R82 inp.n19 inp.t21 153.916
R83 inp.n18 inp.t20 153.916
R84 inp.n17 inp.t19 153.916
R85 inp.n16 inp.t18 153.916
R86 inp.n15 inp.t17 153.916
R87 inp.n14 inp.t16 153.916
R88 inp.n13 inp.t15 153.916
R89 inp.n12 inp.t14 153.916
R90 inp.n11 inp.t13 153.916
R91 inp.n10 inp.t12 153.916
R92 inp.n9 inp.t11 153.916
R93 inp.n8 inp.t10 153.916
R94 inp.n7 inp.t9 153.916
R95 inp.n6 inp.t8 153.916
R96 inp.n5 inp.t7 153.916
R97 inp.n4 inp.t6 153.916
R98 inp.n3 inp.t5 153.916
R99 inp.n2 inp.t4 153.916
R100 inp.n1 inp.t3 153.916
R101 inp.n0 inp.t2 153.916
R102 inp.n23 inp.t0 12.4223
R103 inp.n2 inp.n1 0.909974
R104 inp.n4 inp.n3 0.909974
R105 inp.n6 inp.n5 0.909974
R106 inp.n8 inp.n7 0.909974
R107 inp.n10 inp.n9 0.909974
R108 inp.n14 inp.n13 0.909974
R109 inp.n16 inp.n15 0.909974
R110 inp.n18 inp.n17 0.909974
R111 inp.n20 inp.n19 0.909974
R112 inp.n22 inp.n21 0.909974
R113 inp.n12 inp 0.786816
R114 inp inp.n23 0.308395
R115 inp.n1 inp.n0 0.303658
R116 inp.n3 inp.n2 0.303658
R117 inp.n5 inp.n4 0.303658
R118 inp.n7 inp.n6 0.303658
R119 inp.n9 inp.n8 0.303658
R120 inp.n11 inp.n10 0.303658
R121 inp.n13 inp.n12 0.303658
R122 inp.n15 inp.n14 0.303658
R123 inp.n17 inp.n16 0.303658
R124 inp.n19 inp.n18 0.303658
R125 inp.n21 inp.n20 0.303658
R126 inp.n23 inp.n22 0.289447
R127 inp inp.n11 0.123658
R128 oip.n5 oip.t6 8.65786
R129 oip.n2 oip.n0 8.28208
R130 oip.n2 oip.n1 7.06945
R131 oip.n4 oip.n3 7.06945
R132 oip.n5 oip.n4 4.14997
R133 oip oip.n5 3.69524
R134 oip.n4 oip.n2 1.21313
R135 oip.n0 oip.t1 0.3155
R136 oip.n0 oip.t0 0.3155
R137 oip.n1 oip.t3 0.3155
R138 oip.n1 oip.t2 0.3155
R139 oip.n3 oip.t5 0.3155
R140 oip.n3 oip.t4 0.3155
R141 nb.n31 nb.t7 93.4411
R142 nb.n7 nb.t8 93.3037
R143 nb.n31 nb.t6 93.0858
R144 nb.n32 nb.t5 93.0858
R145 nb.n33 nb.t4 93.0858
R146 nb.n34 nb.t3 93.0858
R147 nb.n35 nb.t2 93.0858
R148 nb.n36 nb.t1 93.0858
R149 nb.n37 nb.t0 93.0858
R150 nb.n29 nb.t31 92.9484
R151 nb.n28 nb.t30 92.9484
R152 nb.n27 nb.t29 92.9484
R153 nb.n26 nb.t28 92.9484
R154 nb.n25 nb.t27 92.9484
R155 nb.n24 nb.t26 92.9484
R156 nb.n23 nb.t25 92.9484
R157 nb.n22 nb.t24 92.9484
R158 nb.n21 nb.t23 92.9484
R159 nb.n20 nb.t22 92.9484
R160 nb.n19 nb.t21 92.9484
R161 nb.n18 nb.t20 92.9484
R162 nb.n17 nb.t19 92.9484
R163 nb.n16 nb.t18 92.9484
R164 nb.n15 nb.t17 92.9484
R165 nb.n14 nb.t16 92.9484
R166 nb.n13 nb.t15 92.9484
R167 nb.n12 nb.t14 92.9484
R168 nb.n11 nb.t13 92.9484
R169 nb.n10 nb.t12 92.9484
R170 nb.n9 nb.t11 92.9484
R171 nb.n8 nb.t10 92.9484
R172 nb.n7 nb.t9 92.9484
R173 nb.n0 nb.t39 92.8489
R174 nb.n0 nb.t38 92.4937
R175 nb.n1 nb.t37 92.4937
R176 nb.n2 nb.t36 92.4937
R177 nb.n3 nb.t35 92.4937
R178 nb.n4 nb.t34 92.4937
R179 nb.n5 nb.t33 92.4937
R180 nb.n6 nb.t32 92.4937
R181 nb.n30 nb 15.8666
R182 nb nb.n38 6.37747
R183 nb.n30 nb.n29 5.63734
R184 nb.n38 nb.n37 5.62076
R185 nb nb.n30 2.79405
R186 nb nb.n6 1.94497
R187 nb.n6 nb.n5 0.355763
R188 nb.n4 nb.n3 0.355763
R189 nb.n2 nb.n1 0.355763
R190 nb.n37 nb.n36 0.355763
R191 nb.n36 nb.n35 0.355763
R192 nb.n35 nb.n34 0.355763
R193 nb.n34 nb.n33 0.355763
R194 nb.n33 nb.n32 0.355763
R195 nb.n32 nb.n31 0.355763
R196 nb.n9 nb.n8 0.355763
R197 nb.n11 nb.n10 0.355763
R198 nb.n13 nb.n12 0.355763
R199 nb.n15 nb.n14 0.355763
R200 nb.n17 nb.n16 0.355763
R201 nb.n19 nb.n18 0.355763
R202 nb.n21 nb.n20 0.355763
R203 nb.n23 nb.n22 0.355763
R204 nb.n25 nb.n24 0.355763
R205 nb.n27 nb.n26 0.355763
R206 nb.n29 nb.n28 0.355763
R207 nb.n38 nb 0.276421
R208 nb.n5 nb.n4 0.251553
R209 nb.n3 nb.n2 0.251553
R210 nb.n1 nb.n0 0.251553
R211 nb.n8 nb.n7 0.251553
R212 nb.n10 nb.n9 0.251553
R213 nb.n12 nb.n11 0.251553
R214 nb.n14 nb.n13 0.251553
R215 nb.n16 nb.n15 0.251553
R216 nb.n18 nb.n17 0.251553
R217 nb.n22 nb.n21 0.251553
R218 nb.n24 nb.n23 0.251553
R219 nb.n26 nb.n25 0.251553
R220 nb.n28 nb.n27 0.251553
R221 nb.n20 nb 0.163921
R222 nb nb.n19 0.0881316
R223 oin.n0 oin.t6 9.41102
R224 oin.n0 oin.t0 6.57918
R225 oin.n5 oin.t5 6.57918
R226 oin.n2 oin.n1 6.26418
R227 oin.n4 oin.n3 6.26418
R228 oin oin.n5 6.15603
R229 oin.n5 oin.n4 1.21313
R230 oin.n4 oin.n2 1.21313
R231 oin.n2 oin.n0 1.21313
R232 oin.n1 oin.t2 0.3155
R233 oin.n1 oin.t1 0.3155
R234 oin.n3 oin.t4 0.3155
R235 oin.n3 oin.t3 0.3155
R236 VDD.n273 VDD.t6 897.516
R237 VDD.n331 VDD.t3 17.7502
R238 VDD.n105 VDD.t5 16.585
R239 VDD.n319 VDD.n318 11.8781
R240 VDD.n332 VDD.n331 10.8135
R241 VDD.n106 VDD.n105 10.5767
R242 VDD.n318 VDD.t4 9.3976
R243 VDD.n331 VDD.t2 8.77392
R244 VDD.n105 VDD.t0 8.18181
R245 VDD.n318 VDD.t1 6.95813
R246 VDD.n104 VDD.n0 5.22661
R247 VDD.n274 VDD.t7 3.42945
R248 VDD.n226 VDD.n225 2.1119
R249 VDD.n112 VDD.n103 1.5755
R250 VDD.n321 VDD.n3 1.5755
R251 VDD.n329 VDD.n328 1.5755
R252 VDD.n286 VDD.n285 1.5755
R253 VDD.n312 VDD.n311 1.5755
R254 VDD.n262 VDD.n28 1.5755
R255 VDD.n279 VDD.n21 1.5755
R256 VDD.n227 VDD.n226 1.5365
R257 VDD.n225 VDD.n46 1.53335
R258 VDD.n112 VDD.n111 1.5005
R259 VDD.n114 VDD.n113 1.5005
R260 VDD.n100 VDD.n99 1.5005
R261 VDD.n120 VDD.n119 1.5005
R262 VDD.n122 VDD.n121 1.5005
R263 VDD.n96 VDD.n95 1.5005
R264 VDD.n128 VDD.n127 1.5005
R265 VDD.n130 VDD.n129 1.5005
R266 VDD.n92 VDD.n91 1.5005
R267 VDD.n136 VDD.n135 1.5005
R268 VDD.n138 VDD.n137 1.5005
R269 VDD.n88 VDD.n87 1.5005
R270 VDD.n144 VDD.n143 1.5005
R271 VDD.n146 VDD.n145 1.5005
R272 VDD.n84 VDD.n83 1.5005
R273 VDD.n152 VDD.n151 1.5005
R274 VDD.n154 VDD.n153 1.5005
R275 VDD.n80 VDD.n79 1.5005
R276 VDD.n160 VDD.n159 1.5005
R277 VDD.n162 VDD.n161 1.5005
R278 VDD.n76 VDD.n75 1.5005
R279 VDD.n168 VDD.n167 1.5005
R280 VDD.n170 VDD.n169 1.5005
R281 VDD.n72 VDD.n71 1.5005
R282 VDD.n176 VDD.n175 1.5005
R283 VDD.n178 VDD.n177 1.5005
R284 VDD.n68 VDD.n67 1.5005
R285 VDD.n184 VDD.n183 1.5005
R286 VDD.n186 VDD.n185 1.5005
R287 VDD.n64 VDD.n63 1.5005
R288 VDD.n192 VDD.n191 1.5005
R289 VDD.n194 VDD.n193 1.5005
R290 VDD.n60 VDD.n59 1.5005
R291 VDD.n200 VDD.n199 1.5005
R292 VDD.n202 VDD.n201 1.5005
R293 VDD.n56 VDD.n55 1.5005
R294 VDD.n208 VDD.n207 1.5005
R295 VDD.n210 VDD.n209 1.5005
R296 VDD.n52 VDD.n51 1.5005
R297 VDD.n216 VDD.n215 1.5005
R298 VDD.n218 VDD.n217 1.5005
R299 VDD.n48 VDD.n47 1.5005
R300 VDD.n224 VDD.n223 1.5005
R301 VDD.n222 VDD.n221 1.5005
R302 VDD.n220 VDD.n219 1.5005
R303 VDD.n50 VDD.n49 1.5005
R304 VDD.n214 VDD.n213 1.5005
R305 VDD.n212 VDD.n211 1.5005
R306 VDD.n54 VDD.n53 1.5005
R307 VDD.n206 VDD.n205 1.5005
R308 VDD.n204 VDD.n203 1.5005
R309 VDD.n58 VDD.n57 1.5005
R310 VDD.n198 VDD.n197 1.5005
R311 VDD.n196 VDD.n195 1.5005
R312 VDD.n62 VDD.n61 1.5005
R313 VDD.n190 VDD.n189 1.5005
R314 VDD.n188 VDD.n187 1.5005
R315 VDD.n66 VDD.n65 1.5005
R316 VDD.n182 VDD.n181 1.5005
R317 VDD.n180 VDD.n179 1.5005
R318 VDD.n70 VDD.n69 1.5005
R319 VDD.n174 VDD.n173 1.5005
R320 VDD.n172 VDD.n171 1.5005
R321 VDD.n74 VDD.n73 1.5005
R322 VDD.n166 VDD.n165 1.5005
R323 VDD.n164 VDD.n163 1.5005
R324 VDD.n78 VDD.n77 1.5005
R325 VDD.n158 VDD.n157 1.5005
R326 VDD.n156 VDD.n155 1.5005
R327 VDD.n82 VDD.n81 1.5005
R328 VDD.n150 VDD.n149 1.5005
R329 VDD.n148 VDD.n147 1.5005
R330 VDD.n86 VDD.n85 1.5005
R331 VDD.n142 VDD.n141 1.5005
R332 VDD.n140 VDD.n139 1.5005
R333 VDD.n90 VDD.n89 1.5005
R334 VDD.n134 VDD.n133 1.5005
R335 VDD.n132 VDD.n131 1.5005
R336 VDD.n94 VDD.n93 1.5005
R337 VDD.n126 VDD.n125 1.5005
R338 VDD.n124 VDD.n123 1.5005
R339 VDD.n98 VDD.n97 1.5005
R340 VDD.n118 VDD.n117 1.5005
R341 VDD.n116 VDD.n115 1.5005
R342 VDD.n102 VDD.n101 1.5005
R343 VDD.n110 VDD.n109 1.5005
R344 VDD.n108 VDD.n107 1.5005
R345 VDD.n45 VDD.n44 1.5005
R346 VDD.n233 VDD.n232 1.5005
R347 VDD.n234 VDD.n43 1.5005
R348 VDD.n236 VDD.n235 1.5005
R349 VDD.n41 VDD.n40 1.5005
R350 VDD.n241 VDD.n240 1.5005
R351 VDD.n242 VDD.n39 1.5005
R352 VDD.n244 VDD.n243 1.5005
R353 VDD.n37 VDD.n36 1.5005
R354 VDD.n249 VDD.n248 1.5005
R355 VDD.n250 VDD.n35 1.5005
R356 VDD.n252 VDD.n251 1.5005
R357 VDD.n33 VDD.n32 1.5005
R358 VDD.n257 VDD.n256 1.5005
R359 VDD.n29 VDD.n28 1.5005
R360 VDD.n268 VDD.n267 1.5005
R361 VDD.n270 VDD.n269 1.5005
R362 VDD.n25 VDD.n24 1.5005
R363 VDD.n278 VDD.n277 1.5005
R364 VDD.n280 VDD.n279 1.5005
R365 VDD.n287 VDD.n286 1.5005
R366 VDD.n18 VDD.n17 1.5005
R367 VDD.n293 VDD.n292 1.5005
R368 VDD.n295 VDD.n294 1.5005
R369 VDD.n14 VDD.n13 1.5005
R370 VDD.n301 VDD.n300 1.5005
R371 VDD.n303 VDD.n302 1.5005
R372 VDD.n10 VDD.n9 1.5005
R373 VDD.n310 VDD.n309 1.5005
R374 VDD.n311 VDD.n8 1.5005
R375 VDD.n4 VDD.n3 1.5005
R376 VDD.n328 VDD.n327 1.5005
R377 VDD.n229 VDD.n228 1.5005
R378 VDD.n230 VDD.n45 1.5005
R379 VDD.n232 VDD.n231 1.5005
R380 VDD.n43 VDD.n42 1.5005
R381 VDD.n237 VDD.n236 1.5005
R382 VDD.n238 VDD.n41 1.5005
R383 VDD.n240 VDD.n239 1.5005
R384 VDD.n39 VDD.n38 1.5005
R385 VDD.n245 VDD.n244 1.5005
R386 VDD.n246 VDD.n37 1.5005
R387 VDD.n248 VDD.n247 1.5005
R388 VDD.n35 VDD.n34 1.5005
R389 VDD.n253 VDD.n252 1.5005
R390 VDD.n254 VDD.n33 1.5005
R391 VDD.n258 VDD.n31 1.5005
R392 VDD.n260 VDD.n259 1.5005
R393 VDD.n261 VDD.n30 1.5005
R394 VDD.n264 VDD.n263 1.5005
R395 VDD.n266 VDD.n265 1.5005
R396 VDD.n27 VDD.n26 1.5005
R397 VDD.n272 VDD.n271 1.5005
R398 VDD.n276 VDD.n275 1.5005
R399 VDD.n23 VDD.n22 1.5005
R400 VDD.n282 VDD.n281 1.5005
R401 VDD.n284 VDD.n283 1.5005
R402 VDD.n20 VDD.n19 1.5005
R403 VDD.n289 VDD.n288 1.5005
R404 VDD.n291 VDD.n290 1.5005
R405 VDD.n16 VDD.n15 1.5005
R406 VDD.n297 VDD.n296 1.5005
R407 VDD.n299 VDD.n298 1.5005
R408 VDD.n12 VDD.n11 1.5005
R409 VDD.n305 VDD.n304 1.5005
R410 VDD.n307 VDD.n306 1.5005
R411 VDD.n308 VDD.n7 1.5005
R412 VDD.n314 VDD.n313 1.5005
R413 VDD.n315 VDD.n6 1.5005
R414 VDD.n317 VDD.n316 1.5005
R415 VDD.n320 VDD.n5 1.5005
R416 VDD.n323 VDD.n322 1.5005
R417 VDD.n326 VDD.n325 1.5005
R418 VDD.n324 VDD.n2 1.5005
R419 VDD.n330 VDD.n1 1.5005
R420 VDD.n334 VDD.n333 1.5005
R421 VDD.n221 VDD.n46 0.854393
R422 VDD.n335 VDD.n334 0.835821
R423 VDD.n255 VDD.n254 0.826
R424 VDD.n108 VDD.n104 0.624924
R425 VDD.n227 VDD.n44 0.606059
R426 VDD.n221 VDD.n220 0.0755
R427 VDD.n220 VDD.n49 0.0755
R428 VDD.n213 VDD.n49 0.0755
R429 VDD.n213 VDD.n212 0.0755
R430 VDD.n212 VDD.n53 0.0755
R431 VDD.n205 VDD.n53 0.0755
R432 VDD.n205 VDD.n204 0.0755
R433 VDD.n204 VDD.n57 0.0755
R434 VDD.n197 VDD.n57 0.0755
R435 VDD.n197 VDD.n196 0.0755
R436 VDD.n196 VDD.n61 0.0755
R437 VDD.n189 VDD.n61 0.0755
R438 VDD.n189 VDD.n188 0.0755
R439 VDD.n188 VDD.n65 0.0755
R440 VDD.n181 VDD.n65 0.0755
R441 VDD.n181 VDD.n180 0.0755
R442 VDD.n180 VDD.n69 0.0755
R443 VDD.n173 VDD.n69 0.0755
R444 VDD.n173 VDD.n172 0.0755
R445 VDD.n172 VDD.n73 0.0755
R446 VDD.n165 VDD.n73 0.0755
R447 VDD.n165 VDD.n164 0.0755
R448 VDD.n164 VDD.n77 0.0755
R449 VDD.n157 VDD.n77 0.0755
R450 VDD.n157 VDD.n156 0.0755
R451 VDD.n156 VDD.n81 0.0755
R452 VDD.n149 VDD.n81 0.0755
R453 VDD.n149 VDD.n148 0.0755
R454 VDD.n148 VDD.n85 0.0755
R455 VDD.n141 VDD.n85 0.0755
R456 VDD.n141 VDD.n140 0.0755
R457 VDD.n140 VDD.n89 0.0755
R458 VDD.n133 VDD.n89 0.0755
R459 VDD.n133 VDD.n132 0.0755
R460 VDD.n132 VDD.n93 0.0755
R461 VDD.n125 VDD.n93 0.0755
R462 VDD.n125 VDD.n124 0.0755
R463 VDD.n124 VDD.n97 0.0755
R464 VDD.n117 VDD.n97 0.0755
R465 VDD.n117 VDD.n116 0.0755
R466 VDD.n116 VDD.n101 0.0755
R467 VDD.n109 VDD.n101 0.0755
R468 VDD.n109 VDD.n108 0.0755
R469 VDD.n230 VDD.n229 0.0755
R470 VDD.n231 VDD.n230 0.0755
R471 VDD.n231 VDD.n42 0.0755
R472 VDD.n237 VDD.n42 0.0755
R473 VDD.n238 VDD.n237 0.0755
R474 VDD.n239 VDD.n238 0.0755
R475 VDD.n239 VDD.n38 0.0755
R476 VDD.n245 VDD.n38 0.0755
R477 VDD.n246 VDD.n245 0.0755
R478 VDD.n247 VDD.n246 0.0755
R479 VDD.n247 VDD.n34 0.0755
R480 VDD.n253 VDD.n34 0.0755
R481 VDD.n254 VDD.n253 0.0755
R482 VDD.n224 VDD.n47 0.0755
R483 VDD.n217 VDD.n47 0.0755
R484 VDD.n217 VDD.n216 0.0755
R485 VDD.n216 VDD.n51 0.0755
R486 VDD.n209 VDD.n51 0.0755
R487 VDD.n209 VDD.n208 0.0755
R488 VDD.n208 VDD.n55 0.0755
R489 VDD.n201 VDD.n55 0.0755
R490 VDD.n201 VDD.n200 0.0755
R491 VDD.n200 VDD.n59 0.0755
R492 VDD.n193 VDD.n59 0.0755
R493 VDD.n193 VDD.n192 0.0755
R494 VDD.n192 VDD.n63 0.0755
R495 VDD.n185 VDD.n63 0.0755
R496 VDD.n185 VDD.n184 0.0755
R497 VDD.n184 VDD.n67 0.0755
R498 VDD.n177 VDD.n67 0.0755
R499 VDD.n177 VDD.n176 0.0755
R500 VDD.n176 VDD.n71 0.0755
R501 VDD.n169 VDD.n71 0.0755
R502 VDD.n169 VDD.n168 0.0755
R503 VDD.n168 VDD.n75 0.0755
R504 VDD.n161 VDD.n75 0.0755
R505 VDD.n161 VDD.n160 0.0755
R506 VDD.n160 VDD.n79 0.0755
R507 VDD.n153 VDD.n79 0.0755
R508 VDD.n153 VDD.n152 0.0755
R509 VDD.n152 VDD.n83 0.0755
R510 VDD.n145 VDD.n83 0.0755
R511 VDD.n145 VDD.n144 0.0755
R512 VDD.n144 VDD.n87 0.0755
R513 VDD.n137 VDD.n87 0.0755
R514 VDD.n137 VDD.n136 0.0755
R515 VDD.n136 VDD.n91 0.0755
R516 VDD.n129 VDD.n91 0.0755
R517 VDD.n129 VDD.n128 0.0755
R518 VDD.n128 VDD.n95 0.0755
R519 VDD.n121 VDD.n95 0.0755
R520 VDD.n121 VDD.n120 0.0755
R521 VDD.n120 VDD.n99 0.0755
R522 VDD.n113 VDD.n99 0.0755
R523 VDD.n113 VDD.n112 0.0755
R524 VDD.n328 VDD.n3 0.0755
R525 VDD.n286 VDD.n17 0.0755
R526 VDD.n293 VDD.n17 0.0755
R527 VDD.n294 VDD.n293 0.0755
R528 VDD.n294 VDD.n13 0.0755
R529 VDD.n301 VDD.n13 0.0755
R530 VDD.n302 VDD.n301 0.0755
R531 VDD.n302 VDD.n9 0.0755
R532 VDD.n310 VDD.n9 0.0755
R533 VDD.n311 VDD.n310 0.0755
R534 VDD.n268 VDD.n28 0.0755
R535 VDD.n269 VDD.n268 0.0755
R536 VDD.n269 VDD.n24 0.0755
R537 VDD.n278 VDD.n24 0.0755
R538 VDD.n279 VDD.n278 0.0755
R539 VDD.n233 VDD.n44 0.0755
R540 VDD.n234 VDD.n233 0.0755
R541 VDD.n235 VDD.n234 0.0755
R542 VDD.n235 VDD.n40 0.0755
R543 VDD.n241 VDD.n40 0.0755
R544 VDD.n242 VDD.n241 0.0755
R545 VDD.n243 VDD.n242 0.0755
R546 VDD.n243 VDD.n36 0.0755
R547 VDD.n249 VDD.n36 0.0755
R548 VDD.n250 VDD.n249 0.0755
R549 VDD.n251 VDD.n250 0.0755
R550 VDD.n251 VDD.n32 0.0755
R551 VDD.n257 VDD.n32 0.0755
R552 VDD.n258 VDD.n257 0.0755
R553 VDD.n259 VDD.n258 0.0755
R554 VDD.n259 VDD.n30 0.0755
R555 VDD.n264 VDD.n30 0.0755
R556 VDD.n265 VDD.n264 0.0755
R557 VDD.n265 VDD.n26 0.0755
R558 VDD.n272 VDD.n26 0.0755
R559 VDD.n282 VDD.n22 0.0755
R560 VDD.n283 VDD.n282 0.0755
R561 VDD.n283 VDD.n19 0.0755
R562 VDD.n289 VDD.n19 0.0755
R563 VDD.n290 VDD.n289 0.0755
R564 VDD.n290 VDD.n15 0.0755
R565 VDD.n297 VDD.n15 0.0755
R566 VDD.n298 VDD.n297 0.0755
R567 VDD.n298 VDD.n11 0.0755
R568 VDD.n305 VDD.n11 0.0755
R569 VDD.n306 VDD.n305 0.0755
R570 VDD.n306 VDD.n7 0.0755
R571 VDD.n314 VDD.n7 0.0755
R572 VDD.n315 VDD.n314 0.0755
R573 VDD.n316 VDD.n315 0.0755
R574 VDD.n316 VDD.n5 0.0755
R575 VDD.n323 VDD.n5 0.0755
R576 VDD.n325 VDD.n323 0.0755
R577 VDD.n325 VDD.n324 0.0755
R578 VDD.n324 VDD.n1 0.0755
R579 VDD.n334 VDD.n1 0.0755
R580 VDD.n228 VDD.n45 0.0755
R581 VDD.n232 VDD.n45 0.0755
R582 VDD.n232 VDD.n43 0.0755
R583 VDD.n236 VDD.n43 0.0755
R584 VDD.n236 VDD.n41 0.0755
R585 VDD.n240 VDD.n41 0.0755
R586 VDD.n240 VDD.n39 0.0755
R587 VDD.n244 VDD.n39 0.0755
R588 VDD.n244 VDD.n37 0.0755
R589 VDD.n248 VDD.n37 0.0755
R590 VDD.n248 VDD.n35 0.0755
R591 VDD.n252 VDD.n35 0.0755
R592 VDD.n252 VDD.n33 0.0755
R593 VDD.n256 VDD.n33 0.0755
R594 VDD.n260 VDD.n31 0.0755
R595 VDD.n261 VDD.n260 0.0755
R596 VDD.n317 VDD.n6 0.0755
R597 VDD.n106 VDD.n104 0.0740762
R598 VDD.n275 VDD.n274 0.071
R599 VDD.n223 VDD.n46 0.0679464
R600 VDD.n229 VDD.n226 0.0665
R601 VDD.n263 VDD.n262 0.062
R602 VDD.n266 VDD.n29 0.062
R603 VDD.n267 VDD.n27 0.062
R604 VDD.n271 VDD.n270 0.062
R605 VDD.n276 VDD.n25 0.062
R606 VDD.n277 VDD.n23 0.062
R607 VDD.n281 VDD.n280 0.062
R608 VDD.n284 VDD.n21 0.062
R609 VDD.n222 VDD.n48 0.060125
R610 VDD.n219 VDD.n218 0.060125
R611 VDD.n215 VDD.n50 0.060125
R612 VDD.n214 VDD.n52 0.060125
R613 VDD.n211 VDD.n210 0.060125
R614 VDD.n207 VDD.n54 0.060125
R615 VDD.n206 VDD.n56 0.060125
R616 VDD.n203 VDD.n202 0.060125
R617 VDD.n199 VDD.n58 0.060125
R618 VDD.n198 VDD.n60 0.060125
R619 VDD.n195 VDD.n194 0.060125
R620 VDD.n191 VDD.n62 0.060125
R621 VDD.n190 VDD.n64 0.060125
R622 VDD.n187 VDD.n186 0.060125
R623 VDD.n183 VDD.n66 0.060125
R624 VDD.n182 VDD.n68 0.060125
R625 VDD.n179 VDD.n178 0.060125
R626 VDD.n175 VDD.n70 0.060125
R627 VDD.n174 VDD.n72 0.060125
R628 VDD.n171 VDD.n170 0.060125
R629 VDD.n167 VDD.n74 0.060125
R630 VDD.n166 VDD.n76 0.060125
R631 VDD.n163 VDD.n162 0.060125
R632 VDD.n159 VDD.n78 0.060125
R633 VDD.n158 VDD.n80 0.060125
R634 VDD.n155 VDD.n154 0.060125
R635 VDD.n151 VDD.n82 0.060125
R636 VDD.n150 VDD.n84 0.060125
R637 VDD.n147 VDD.n146 0.060125
R638 VDD.n143 VDD.n86 0.060125
R639 VDD.n142 VDD.n88 0.060125
R640 VDD.n139 VDD.n138 0.060125
R641 VDD.n135 VDD.n90 0.060125
R642 VDD.n134 VDD.n92 0.060125
R643 VDD.n131 VDD.n130 0.060125
R644 VDD.n127 VDD.n94 0.060125
R645 VDD.n126 VDD.n96 0.060125
R646 VDD.n123 VDD.n122 0.060125
R647 VDD.n119 VDD.n98 0.060125
R648 VDD.n118 VDD.n100 0.060125
R649 VDD.n115 VDD.n114 0.060125
R650 VDD.n111 VDD.n102 0.060125
R651 VDD.n110 VDD.n103 0.060125
R652 VDD.n321 VDD.n320 0.060125
R653 VDD.n322 VDD.n4 0.060125
R654 VDD.n327 VDD.n326 0.060125
R655 VDD.n329 VDD.n2 0.060125
R656 VDD.n285 VDD.n284 0.0575
R657 VDD.n287 VDD.n20 0.0575
R658 VDD.n288 VDD.n18 0.0575
R659 VDD.n292 VDD.n291 0.0575
R660 VDD.n295 VDD.n16 0.0575
R661 VDD.n296 VDD.n14 0.0575
R662 VDD.n300 VDD.n299 0.0575
R663 VDD.n303 VDD.n12 0.0575
R664 VDD.n304 VDD.n10 0.0575
R665 VDD.n309 VDD.n307 0.0575
R666 VDD.n308 VDD.n8 0.0575
R667 VDD.n313 VDD.n312 0.0575
R668 VDD.n335 VDD.n0 0.0568929
R669 VDD.n273 VDD.n272 0.051875
R670 VDD.n225 VDD.n224 0.051125
R671 VDD.n228 VDD.n227 0.0471877
R672 VDD.n333 VDD.n332 0.045875
R673 VDD.n333 VDD.n0 0.0455
R674 VDD.n319 VDD.n317 0.0449375
R675 VDD.n255 VDD.n31 0.0385
R676 VDD.n256 VDD.n255 0.0367143
R677 VDD.n320 VDD.n319 0.0310625
R678 VDD.n107 VDD.n106 0.030125
R679 VDD.n332 VDD.n330 0.030125
R680 VDD VDD.n335 0.0285435
R681 VDD.n275 VDD.n273 0.024125
R682 VDD.n285 VDD.n20 0.0185
R683 VDD.n288 VDD.n287 0.0185
R684 VDD.n291 VDD.n18 0.0185
R685 VDD.n292 VDD.n16 0.0185
R686 VDD.n296 VDD.n295 0.0185
R687 VDD.n299 VDD.n14 0.0185
R688 VDD.n300 VDD.n12 0.0185
R689 VDD.n304 VDD.n303 0.0185
R690 VDD.n307 VDD.n10 0.0185
R691 VDD.n309 VDD.n308 0.0185
R692 VDD.n313 VDD.n8 0.0185
R693 VDD.n312 VDD.n6 0.0185
R694 VDD.n223 VDD.n222 0.015875
R695 VDD.n219 VDD.n48 0.015875
R696 VDD.n218 VDD.n50 0.015875
R697 VDD.n215 VDD.n214 0.015875
R698 VDD.n211 VDD.n52 0.015875
R699 VDD.n210 VDD.n54 0.015875
R700 VDD.n207 VDD.n206 0.015875
R701 VDD.n203 VDD.n56 0.015875
R702 VDD.n202 VDD.n58 0.015875
R703 VDD.n199 VDD.n198 0.015875
R704 VDD.n195 VDD.n60 0.015875
R705 VDD.n194 VDD.n62 0.015875
R706 VDD.n191 VDD.n190 0.015875
R707 VDD.n187 VDD.n64 0.015875
R708 VDD.n186 VDD.n66 0.015875
R709 VDD.n183 VDD.n182 0.015875
R710 VDD.n179 VDD.n68 0.015875
R711 VDD.n178 VDD.n70 0.015875
R712 VDD.n175 VDD.n174 0.015875
R713 VDD.n171 VDD.n72 0.015875
R714 VDD.n170 VDD.n74 0.015875
R715 VDD.n167 VDD.n166 0.015875
R716 VDD.n163 VDD.n76 0.015875
R717 VDD.n162 VDD.n78 0.015875
R718 VDD.n159 VDD.n158 0.015875
R719 VDD.n155 VDD.n80 0.015875
R720 VDD.n154 VDD.n82 0.015875
R721 VDD.n151 VDD.n150 0.015875
R722 VDD.n147 VDD.n84 0.015875
R723 VDD.n146 VDD.n86 0.015875
R724 VDD.n143 VDD.n142 0.015875
R725 VDD.n139 VDD.n88 0.015875
R726 VDD.n138 VDD.n90 0.015875
R727 VDD.n135 VDD.n134 0.015875
R728 VDD.n131 VDD.n92 0.015875
R729 VDD.n130 VDD.n94 0.015875
R730 VDD.n127 VDD.n126 0.015875
R731 VDD.n123 VDD.n96 0.015875
R732 VDD.n122 VDD.n98 0.015875
R733 VDD.n119 VDD.n118 0.015875
R734 VDD.n115 VDD.n100 0.015875
R735 VDD.n114 VDD.n102 0.015875
R736 VDD.n111 VDD.n110 0.015875
R737 VDD.n107 VDD.n103 0.015875
R738 VDD.n322 VDD.n321 0.015875
R739 VDD.n326 VDD.n4 0.015875
R740 VDD.n327 VDD.n2 0.015875
R741 VDD.n330 VDD.n329 0.015875
R742 VDD.n262 VDD.n261 0.014
R743 VDD.n263 VDD.n29 0.014
R744 VDD.n267 VDD.n266 0.014
R745 VDD.n270 VDD.n27 0.014
R746 VDD.n271 VDD.n25 0.014
R747 VDD.n277 VDD.n276 0.014
R748 VDD.n280 VDD.n23 0.014
R749 VDD.n281 VDD.n21 0.014
R750 VDD.n274 VDD.n22 0.005
R751 VSS.n310 VSS.n43 697082
R752 VSS.t60 VSS.n43 32908.3
R753 VSS.n310 VSS.t64 30577.3
R754 VSS.t58 VSS.t60 1470.29
R755 VSS.t62 VSS.t58 1069.3
R756 VSS.t64 VSS.t45 564.056
R757 VSS.t50 VSS.t155 503.908
R758 VSS.t169 VSS.t65 501.235
R759 VSS.t26 VSS.t62 307.423
R760 VSS.t91 VSS.t90 218.386
R761 VSS.t167 VSS.t169 200.494
R762 VSS.t165 VSS.t167 200.494
R763 VSS.t163 VSS.t165 200.494
R764 VSS.t161 VSS.t163 200.494
R765 VSS.t159 VSS.t161 200.494
R766 VSS.t157 VSS.t159 200.494
R767 VSS.t155 VSS.t157 200.494
R768 VSS.t38 VSS.t50 171.089
R769 VSS.t37 VSS.t38 171.089
R770 VSS.t49 VSS.t37 171.089
R771 VSS.t48 VSS.t49 171.089
R772 VSS.t36 VSS.t48 171.089
R773 VSS.t35 VSS.t36 171.089
R774 VSS.t47 VSS.t35 171.089
R775 VSS.t46 VSS.t47 171.089
R776 VSS.t34 VSS.t46 171.089
R777 VSS.t33 VSS.t34 171.089
R778 VSS.t45 VSS.t33 171.089
R779 VSS.t65 VSS.t26 162.957
R780 VSS.n43 VSS.t153 157.685
R781 VSS.t153 VSS.t151 101.733
R782 VSS.t149 VSS.t147 101.733
R783 VSS.t145 VSS.t143 101.733
R784 VSS.t141 VSS.t139 101.733
R785 VSS.t137 VSS.t135 101.733
R786 VSS.t133 VSS.t131 101.733
R787 VSS.t129 VSS.t127 101.733
R788 VSS.t125 VSS.t123 101.733
R789 VSS.t121 VSS.t119 101.733
R790 VSS.t117 VSS.t115 101.733
R791 VSS.t113 VSS.t111 101.733
R792 VSS.t93 VSS.t91 101.733
R793 VSS.t24 VSS.n310 89.8638
R794 VSS.t90 VSS.t23 86.8118
R795 VSS.t22 VSS.t89 86.8118
R796 VSS.t89 VSS.t88 86.8118
R797 VSS.t88 VSS.t21 86.8118
R798 VSS.t21 VSS.t20 86.8118
R799 VSS.t20 VSS.t87 86.8118
R800 VSS.t87 VSS.t86 86.8118
R801 VSS.t86 VSS.t19 86.8118
R802 VSS.t19 VSS.t18 86.8118
R803 VSS.t85 VSS.t84 86.8118
R804 VSS.t84 VSS.t17 86.8118
R805 VSS.t17 VSS.t16 86.8118
R806 VSS.t16 VSS.t83 86.8118
R807 VSS.t83 VSS.t82 86.8118
R808 VSS.t81 VSS.t80 86.8118
R809 VSS.t80 VSS.t13 86.8118
R810 VSS.t2 VSS.t70 86.8118
R811 VSS.t70 VSS.t24 84.099
R812 VSS.t23 VSS.t54 80.7079
R813 VSS.t66 VSS.t32 80.0297
R814 VSS.t75 VSS.t31 80.0297
R815 VSS.t7 VSS.t43 80.0297
R816 VSS.t6 VSS.t42 80.0297
R817 VSS.t74 VSS.t30 80.0297
R818 VSS.t73 VSS.t29 80.0297
R819 VSS.t40 VSS.t4 80.0297
R820 VSS.t27 VSS.t71 80.0297
R821 VSS.t3 VSS.t39 80.0297
R822 VSS.t3 VSS.t28 75.9604
R823 VSS.t151 VSS.t149 71.8911
R824 VSS.t147 VSS.t145 71.8911
R825 VSS.t143 VSS.t141 71.8911
R826 VSS.t139 VSS.t137 71.8911
R827 VSS.t135 VSS.t133 71.8911
R828 VSS.t131 VSS.t129 71.8911
R829 VSS.t127 VSS.t125 71.8911
R830 VSS.t123 VSS.t121 71.8911
R831 VSS.t119 VSS.t117 71.8911
R832 VSS.t111 VSS.t93 71.8911
R833 VSS.t3 VSS.t41 71.8911
R834 VSS.t109 VSS.t12 66.4654
R835 VSS.t97 VSS.t76 66.4654
R836 VSS.t56 VSS.t113 54.9358
R837 VSS.t99 VSS.t77 51.5447
R838 VSS.t95 VSS.t9 51.5447
R839 VSS.n311 VSS.t52 48.8319
R840 VSS.n41 VSS.t8 39.0553
R841 VSS.t76 VSS.t95 35.2676
R842 VSS.t82 VSS.t67 33.9112
R843 VSS.t0 VSS.t51 33.9112
R844 VSS.t25 VSS.t99 28.4855
R845 VSS.t67 VSS.t15 25.3928
R846 VSS.n52 VSS.t63 24.8138
R847 VSS.t67 VSS.t14 23.8013
R848 VSS.t67 VSS.t81 23.0598
R849 VSS.n311 VSS.t85 22.3816
R850 VSS.t13 VSS.t109 20.3469
R851 VSS.t77 VSS.t97 20.3469
R852 VSS.t115 VSS.t56 16.9558
R853 VSS.t18 VSS.t52 15.5994
R854 VSS.t25 VSS.t103 14.3946
R855 VSS.t25 VSS.t107 14.3627
R856 VSS.t24 VSS.t68 14.1712
R857 VSS.t26 VSS.n309 12.8509
R858 VSS.n42 VSS.t1 11.0887
R859 VSS.t12 VSS.t25 8.13906
R860 VSS.t5 VSS.t3 8.13906
R861 VSS.n40 VSS.t11 7.66083
R862 VSS.n39 VSS.t79 7.42146
R863 VSS.t32 VSS.t75 6.78264
R864 VSS.t43 VSS.t6 6.78264
R865 VSS.t42 VSS.t74 6.78264
R866 VSS.t30 VSS.t73 6.78264
R867 VSS.t29 VSS.t5 6.78264
R868 VSS.t4 VSS.t41 6.78264
R869 VSS.t72 VSS.t40 6.78264
R870 VSS.t71 VSS.t28 6.78264
R871 VSS.t3 VSS.t27 6.78264
R872 VSS.t39 VSS.t2 6.78264
R873 VSS.t25 VSS.t78 6.49539
R874 VSS.t54 VSS.t22 6.10442
R875 VSS.t25 VSS.t10 5.98474
R876 VSS.t25 VSS.n39 5.93737
R877 VSS.t25 VSS.n40 5.87353
R878 VSS.n39 VSS.t105 5.74587
R879 VSS.n40 VSS.t101 5.5065
R880 VSS.n382 VSS.n381 5.42634
R881 VSS.n155 VSS.n154 5.41838
R882 VSS.t9 VSS.t66 4.06978
R883 VSS.t66 VSS.t7 4.06978
R884 VSS.t3 VSS.t72 4.06978
R885 VSS.t24 VSS.t0 3.39157
R886 VSS.t66 VSS.n41 3.31068
R887 VSS.n41 VSS.t44 3.20217
R888 VSS.t66 VSS.t31 2.71335
R889 VSS.t24 VSS.t69 2.58569
R890 VSS.t24 VSS.n42 2.1779
R891 VSS.n167 VSS.t61 1.96739
R892 VSS.t59 VSS.n53 1.96739
R893 VSS.n292 VSS.t170 1.94182
R894 VSS.n274 VSS.t156 1.94182
R895 VSS.t57 VSS.n116 1.81678
R896 VSS.n323 VSS.t53 1.81678
R897 VSS.n339 VSS.t110 1.79377
R898 VSS.n13 VSS.t96 1.79377
R899 VSS.n119 VSS.t92 1.79377
R900 VSS.n74 VSS.t154 1.79377
R901 VSS.n69 VSS.n61 1.64695
R902 VSS.n118 VSS.n117 1.64695
R903 VSS.n322 VSS.n321 1.64695
R904 VSS.n221 VSS.n220 1.62682
R905 VSS.n283 VSS.n226 1.62682
R906 VSS.n228 VSS.n227 1.62682
R907 VSS.n342 VSS.n340 1.62682
R908 VSS.n19 VSS.n18 1.62682
R909 VSS.n351 VSS.n17 1.62682
R910 VSS.n110 VSS.n109 1.62682
R911 VSS.n106 VSS.n102 1.62682
R912 VSS.n104 VSS.n103 1.62682
R913 VSS.n115 VSS.n114 1.62682
R914 VSS.n97 VSS.n96 1.62682
R915 VSS.n93 VSS.n92 1.62682
R916 VSS.n88 VSS.n87 1.62682
R917 VSS.n85 VSS.n84 1.62682
R918 VSS.n79 VSS.n78 1.62682
R919 VSS.n149 VSS.n77 1.62682
R920 VSS.n151 VSS.n76 1.62682
R921 VSS.n382 VSS.n1 1.57925
R922 VSS.n156 VSS.n72 1.5755
R923 VSS.n198 VSS.n197 1.5755
R924 VSS.n204 VSS.n203 1.5755
R925 VSS.n247 VSS.n243 1.5755
R926 VSS.n372 VSS.n371 1.5755
R927 VSS.n380 VSS.n379 1.5755
R928 VSS.n334 VSS.n25 1.5755
R929 VSS.n365 VSS.n364 1.5755
R930 VSS.n122 VSS.n35 1.5755
R931 VSS.n328 VSS.n327 1.5755
R932 VSS.n154 VSS.n74 1.52544
R933 VSS.n153 VSS.n152 1.5005
R934 VSS.n150 VSS.n75 1.5005
R935 VSS.n148 VSS.n147 1.5005
R936 VSS.n82 VSS.n80 1.5005
R937 VSS.n144 VSS.n83 1.5005
R938 VSS.n143 VSS.n86 1.5005
R939 VSS.n142 VSS.n89 1.5005
R940 VSS.n94 VSS.n90 1.5005
R941 VSS.n138 VSS.n95 1.5005
R942 VSS.n137 VSS.n98 1.5005
R943 VSS.n136 VSS.n99 1.5005
R944 VSS.n105 VSS.n100 1.5005
R945 VSS.n132 VSS.n107 1.5005
R946 VSS.n131 VSS.n108 1.5005
R947 VSS.n130 VSS.n111 1.5005
R948 VSS.n120 VSS.n112 1.5005
R949 VSS.n35 VSS.n33 1.5005
R950 VSS.n318 VSS.n317 1.5005
R951 VSS.n316 VSS.n315 1.5005
R952 VSS.n38 VSS.n36 1.5005
R953 VSS.n29 VSS.n28 1.5005
R954 VSS.n327 VSS.n326 1.5005
R955 VSS.n334 VSS.n333 1.5005
R956 VSS.n336 VSS.n335 1.5005
R957 VSS.n22 VSS.n21 1.5005
R958 VSS.n346 VSS.n345 1.5005
R959 VSS.n348 VSS.n347 1.5005
R960 VSS.n16 VSS.n15 1.5005
R961 VSS.n356 VSS.n355 1.5005
R962 VSS.n358 VSS.n357 1.5005
R963 VSS.n12 VSS.n11 1.5005
R964 VSS.n364 VSS.n363 1.5005
R965 VSS.n373 VSS.n372 1.5005
R966 VSS.n5 VSS.n4 1.5005
R967 VSS.n379 VSS.n378 1.5005
R968 VSS.n145 VSS.n144 1.5005
R969 VSS.n143 VSS.n81 1.5005
R970 VSS.n142 VSS.n141 1.5005
R971 VSS.n140 VSS.n90 1.5005
R972 VSS.n139 VSS.n138 1.5005
R973 VSS.n137 VSS.n91 1.5005
R974 VSS.n136 VSS.n135 1.5005
R975 VSS.n134 VSS.n100 1.5005
R976 VSS.n133 VSS.n132 1.5005
R977 VSS.n131 VSS.n101 1.5005
R978 VSS.n130 VSS.n129 1.5005
R979 VSS.n127 VSS.n126 1.5005
R980 VSS.n125 VSS.n113 1.5005
R981 VSS.n124 VSS.n123 1.5005
R982 VSS.n121 VSS.n31 1.5005
R983 VSS.n320 VSS.n319 1.5005
R984 VSS.n34 VSS.n32 1.5005
R985 VSS.n314 VSS.n313 1.5005
R986 VSS.n37 VSS.n30 1.5005
R987 VSS.n325 VSS.n324 1.5005
R988 VSS.n27 VSS.n26 1.5005
R989 VSS.n330 VSS.n329 1.5005
R990 VSS.n332 VSS.n331 1.5005
R991 VSS.n24 VSS.n23 1.5005
R992 VSS.n338 VSS.n337 1.5005
R993 VSS.n344 VSS.n343 1.5005
R994 VSS.n341 VSS.n20 1.5005
R995 VSS.n350 VSS.n349 1.5005
R996 VSS.n354 VSS.n353 1.5005
R997 VSS.n352 VSS.n14 1.5005
R998 VSS.n360 VSS.n359 1.5005
R999 VSS.n362 VSS.n361 1.5005
R1000 VSS.n10 VSS.n9 1.5005
R1001 VSS.n367 VSS.n366 1.5005
R1002 VSS.n368 VSS.n8 1.5005
R1003 VSS.n370 VSS.n369 1.5005
R1004 VSS.n7 VSS.n6 1.5005
R1005 VSS.n375 VSS.n374 1.5005
R1006 VSS.n377 VSS.n376 1.5005
R1007 VSS.n3 VSS.n2 1.5005
R1008 VSS.n244 VSS.n243 1.5005
R1009 VSS.n253 VSS.n252 1.5005
R1010 VSS.n255 VSS.n254 1.5005
R1011 VSS.n240 VSS.n239 1.5005
R1012 VSS.n261 VSS.n260 1.5005
R1013 VSS.n263 VSS.n262 1.5005
R1014 VSS.n236 VSS.n235 1.5005
R1015 VSS.n269 VSS.n268 1.5005
R1016 VSS.n271 VSS.n270 1.5005
R1017 VSS.n231 VSS.n230 1.5005
R1018 VSS.n278 VSS.n277 1.5005
R1019 VSS.n280 VSS.n279 1.5005
R1020 VSS.n224 VSS.n223 1.5005
R1021 VSS.n287 VSS.n286 1.5005
R1022 VSS.n289 VSS.n288 1.5005
R1023 VSS.n219 VSS.n218 1.5005
R1024 VSS.n296 VSS.n295 1.5005
R1025 VSS.n298 VSS.n297 1.5005
R1026 VSS.n215 VSS.n214 1.5005
R1027 VSS.n304 VSS.n303 1.5005
R1028 VSS.n306 VSS.n305 1.5005
R1029 VSS.n213 VSS.n46 1.5005
R1030 VSS.n212 VSS.n211 1.5005
R1031 VSS.n49 VSS.n48 1.5005
R1032 VSS.n205 VSS.n204 1.5005
R1033 VSS.n197 VSS.n196 1.5005
R1034 VSS.n56 VSS.n55 1.5005
R1035 VSS.n190 VSS.n189 1.5005
R1036 VSS.n188 VSS.n187 1.5005
R1037 VSS.n60 VSS.n59 1.5005
R1038 VSS.n182 VSS.n181 1.5005
R1039 VSS.n180 VSS.n179 1.5005
R1040 VSS.n64 VSS.n63 1.5005
R1041 VSS.n173 VSS.n172 1.5005
R1042 VSS.n171 VSS.n170 1.5005
R1043 VSS.n68 VSS.n67 1.5005
R1044 VSS.n164 VSS.n163 1.5005
R1045 VSS.n162 VSS.n161 1.5005
R1046 VSS.n73 VSS.n72 1.5005
R1047 VSS.n158 VSS.n157 1.5005
R1048 VSS.n160 VSS.n159 1.5005
R1049 VSS.n71 VSS.n70 1.5005
R1050 VSS.n166 VSS.n165 1.5005
R1051 VSS.n169 VSS.n168 1.5005
R1052 VSS.n66 VSS.n65 1.5005
R1053 VSS.n175 VSS.n174 1.5005
R1054 VSS.n178 VSS.n177 1.5005
R1055 VSS.n176 VSS.n62 1.5005
R1056 VSS.n184 VSS.n183 1.5005
R1057 VSS.n186 VSS.n185 1.5005
R1058 VSS.n58 VSS.n57 1.5005
R1059 VSS.n192 VSS.n191 1.5005
R1060 VSS.n195 VSS.n194 1.5005
R1061 VSS.n193 VSS.n54 1.5005
R1062 VSS.n200 VSS.n199 1.5005
R1063 VSS.n202 VSS.n201 1.5005
R1064 VSS.n51 VSS.n50 1.5005
R1065 VSS.n207 VSS.n206 1.5005
R1066 VSS.n209 VSS.n208 1.5005
R1067 VSS.n210 VSS.n44 1.5005
R1068 VSS.n308 VSS.n307 1.5005
R1069 VSS.n47 VSS.n45 1.5005
R1070 VSS.n302 VSS.n301 1.5005
R1071 VSS.n300 VSS.n299 1.5005
R1072 VSS.n217 VSS.n216 1.5005
R1073 VSS.n294 VSS.n293 1.5005
R1074 VSS.n291 VSS.n290 1.5005
R1075 VSS.n225 VSS.n222 1.5005
R1076 VSS.n285 VSS.n284 1.5005
R1077 VSS.n282 VSS.n281 1.5005
R1078 VSS.n232 VSS.n229 1.5005
R1079 VSS.n276 VSS.n275 1.5005
R1080 VSS.n273 VSS.n272 1.5005
R1081 VSS.n234 VSS.n233 1.5005
R1082 VSS.n267 VSS.n266 1.5005
R1083 VSS.n265 VSS.n264 1.5005
R1084 VSS.n238 VSS.n237 1.5005
R1085 VSS.n259 VSS.n258 1.5005
R1086 VSS.n257 VSS.n256 1.5005
R1087 VSS.n242 VSS.n241 1.5005
R1088 VSS.n251 VSS.n250 1.5005
R1089 VSS.n249 VSS.n248 1.5005
R1090 VSS.n246 VSS.n245 1.5005
R1091 VSS.n1 VSS.n0 1.5005
R1092 VSS.t51 VSS.n42 1.29788
R1093 VSS.n146 VSS.n145 0.826
R1094 VSS.n129 VSS.n128 0.826
R1095 VSS.n158 VSS.n155 0.589
R1096 VSS.n381 VSS.n2 0.585263
R1097 VSS.t61 VSS.n69 0.320948
R1098 VSS.n69 VSS.t59 0.320948
R1099 VSS.n220 VSS.t168 0.3155
R1100 VSS.n220 VSS.t166 0.3155
R1101 VSS.n226 VSS.t164 0.3155
R1102 VSS.n226 VSS.t162 0.3155
R1103 VSS.n227 VSS.t160 0.3155
R1104 VSS.n227 VSS.t158 0.3155
R1105 VSS.n117 VSS.t57 0.179951
R1106 VSS.n117 VSS.t55 0.179951
R1107 VSS.n322 VSS.t55 0.179951
R1108 VSS.t53 VSS.n322 0.179951
R1109 VSS.n340 VSS.t108 0.1769
R1110 VSS.n340 VSS.t106 0.1769
R1111 VSS.n18 VSS.t104 0.1769
R1112 VSS.n18 VSS.t102 0.1769
R1113 VSS.n17 VSS.t100 0.1769
R1114 VSS.n17 VSS.t98 0.1769
R1115 VSS.n109 VSS.t112 0.1769
R1116 VSS.n109 VSS.t94 0.1769
R1117 VSS.n102 VSS.t116 0.1769
R1118 VSS.n102 VSS.t114 0.1769
R1119 VSS.n103 VSS.t120 0.1769
R1120 VSS.n103 VSS.t118 0.1769
R1121 VSS.n114 VSS.t124 0.1769
R1122 VSS.n114 VSS.t122 0.1769
R1123 VSS.n96 VSS.t128 0.1769
R1124 VSS.n96 VSS.t126 0.1769
R1125 VSS.n92 VSS.t132 0.1769
R1126 VSS.n92 VSS.t130 0.1769
R1127 VSS.n87 VSS.t136 0.1769
R1128 VSS.n87 VSS.t134 0.1769
R1129 VSS.n84 VSS.t140 0.1769
R1130 VSS.n84 VSS.t138 0.1769
R1131 VSS.n78 VSS.t144 0.1769
R1132 VSS.n78 VSS.t142 0.1769
R1133 VSS.n77 VSS.t148 0.1769
R1134 VSS.n77 VSS.t146 0.1769
R1135 VSS.n76 VSS.t152 0.1769
R1136 VSS.n76 VSS.t150 0.1769
R1137 VSS.n156 VSS.n155 0.118812
R1138 VSS.n381 VSS.n380 0.117112
R1139 VSS.n162 VSS.n72 0.0755
R1140 VSS.n163 VSS.n162 0.0755
R1141 VSS.n163 VSS.n67 0.0755
R1142 VSS.n171 VSS.n67 0.0755
R1143 VSS.n172 VSS.n171 0.0755
R1144 VSS.n172 VSS.n63 0.0755
R1145 VSS.n180 VSS.n63 0.0755
R1146 VSS.n181 VSS.n180 0.0755
R1147 VSS.n181 VSS.n59 0.0755
R1148 VSS.n188 VSS.n59 0.0755
R1149 VSS.n189 VSS.n188 0.0755
R1150 VSS.n189 VSS.n55 0.0755
R1151 VSS.n197 VSS.n55 0.0755
R1152 VSS.n204 VSS.n48 0.0755
R1153 VSS.n212 VSS.n48 0.0755
R1154 VSS.n213 VSS.n212 0.0755
R1155 VSS.n305 VSS.n213 0.0755
R1156 VSS.n305 VSS.n304 0.0755
R1157 VSS.n304 VSS.n214 0.0755
R1158 VSS.n297 VSS.n214 0.0755
R1159 VSS.n297 VSS.n296 0.0755
R1160 VSS.n296 VSS.n218 0.0755
R1161 VSS.n288 VSS.n218 0.0755
R1162 VSS.n288 VSS.n287 0.0755
R1163 VSS.n287 VSS.n223 0.0755
R1164 VSS.n279 VSS.n223 0.0755
R1165 VSS.n279 VSS.n278 0.0755
R1166 VSS.n278 VSS.n230 0.0755
R1167 VSS.n270 VSS.n230 0.0755
R1168 VSS.n270 VSS.n269 0.0755
R1169 VSS.n269 VSS.n235 0.0755
R1170 VSS.n262 VSS.n235 0.0755
R1171 VSS.n262 VSS.n261 0.0755
R1172 VSS.n261 VSS.n239 0.0755
R1173 VSS.n254 VSS.n239 0.0755
R1174 VSS.n254 VSS.n253 0.0755
R1175 VSS.n253 VSS.n243 0.0755
R1176 VSS.n145 VSS.n81 0.0755
R1177 VSS.n141 VSS.n81 0.0755
R1178 VSS.n141 VSS.n140 0.0755
R1179 VSS.n140 VSS.n139 0.0755
R1180 VSS.n139 VSS.n91 0.0755
R1181 VSS.n135 VSS.n91 0.0755
R1182 VSS.n135 VSS.n134 0.0755
R1183 VSS.n134 VSS.n133 0.0755
R1184 VSS.n133 VSS.n101 0.0755
R1185 VSS.n129 VSS.n101 0.0755
R1186 VSS.n372 VSS.n4 0.0755
R1187 VSS.n379 VSS.n4 0.0755
R1188 VSS.n335 VSS.n334 0.0755
R1189 VSS.n335 VSS.n21 0.0755
R1190 VSS.n346 VSS.n21 0.0755
R1191 VSS.n347 VSS.n346 0.0755
R1192 VSS.n347 VSS.n15 0.0755
R1193 VSS.n356 VSS.n15 0.0755
R1194 VSS.n357 VSS.n356 0.0755
R1195 VSS.n357 VSS.n11 0.0755
R1196 VSS.n364 VSS.n11 0.0755
R1197 VSS.n317 VSS.n35 0.0755
R1198 VSS.n317 VSS.n316 0.0755
R1199 VSS.n316 VSS.n36 0.0755
R1200 VSS.n36 VSS.n28 0.0755
R1201 VSS.n327 VSS.n28 0.0755
R1202 VSS.n159 VSS.n158 0.0755
R1203 VSS.n159 VSS.n70 0.0755
R1204 VSS.n166 VSS.n70 0.0755
R1205 VSS.n168 VSS.n65 0.0755
R1206 VSS.n175 VSS.n65 0.0755
R1207 VSS.n177 VSS.n175 0.0755
R1208 VSS.n177 VSS.n176 0.0755
R1209 VSS.n185 VSS.n184 0.0755
R1210 VSS.n185 VSS.n57 0.0755
R1211 VSS.n192 VSS.n57 0.0755
R1212 VSS.n194 VSS.n192 0.0755
R1213 VSS.n194 VSS.n193 0.0755
R1214 VSS.n201 VSS.n200 0.0755
R1215 VSS.n201 VSS.n50 0.0755
R1216 VSS.n207 VSS.n50 0.0755
R1217 VSS.n208 VSS.n207 0.0755
R1218 VSS.n208 VSS.n44 0.0755
R1219 VSS.n308 VSS.n45 0.0755
R1220 VSS.n301 VSS.n45 0.0755
R1221 VSS.n301 VSS.n300 0.0755
R1222 VSS.n300 VSS.n216 0.0755
R1223 VSS.n293 VSS.n216 0.0755
R1224 VSS.n284 VSS.n225 0.0755
R1225 VSS.n275 VSS.n232 0.0755
R1226 VSS.n273 VSS.n233 0.0755
R1227 VSS.n266 VSS.n233 0.0755
R1228 VSS.n266 VSS.n265 0.0755
R1229 VSS.n265 VSS.n237 0.0755
R1230 VSS.n258 VSS.n237 0.0755
R1231 VSS.n258 VSS.n257 0.0755
R1232 VSS.n257 VSS.n241 0.0755
R1233 VSS.n250 VSS.n241 0.0755
R1234 VSS.n250 VSS.n249 0.0755
R1235 VSS.n249 VSS.n245 0.0755
R1236 VSS.n245 VSS.n1 0.0755
R1237 VSS.n83 VSS.n82 0.0755
R1238 VSS.n95 VSS.n94 0.0755
R1239 VSS.n108 VSS.n107 0.0755
R1240 VSS.n126 VSS.n120 0.0755
R1241 VSS.n126 VSS.n125 0.0755
R1242 VSS.n125 VSS.n124 0.0755
R1243 VSS.n124 VSS.n31 0.0755
R1244 VSS.n320 VSS.n32 0.0755
R1245 VSS.n313 VSS.n32 0.0755
R1246 VSS.n324 VSS.n30 0.0755
R1247 VSS.n330 VSS.n26 0.0755
R1248 VSS.n331 VSS.n330 0.0755
R1249 VSS.n331 VSS.n23 0.0755
R1250 VSS.n338 VSS.n23 0.0755
R1251 VSS.n353 VSS.n352 0.0755
R1252 VSS.n361 VSS.n360 0.0755
R1253 VSS.n361 VSS.n9 0.0755
R1254 VSS.n367 VSS.n9 0.0755
R1255 VSS.n368 VSS.n367 0.0755
R1256 VSS.n369 VSS.n368 0.0755
R1257 VSS.n369 VSS.n6 0.0755
R1258 VSS.n375 VSS.n6 0.0755
R1259 VSS.n376 VSS.n375 0.0755
R1260 VSS.n376 VSS.n2 0.0755
R1261 VSS.n153 VSS.n75 0.0755
R1262 VSS.n147 VSS.n75 0.0755
R1263 VSS.n144 VSS.n80 0.0755
R1264 VSS.n144 VSS.n143 0.0755
R1265 VSS.n143 VSS.n142 0.0755
R1266 VSS.n142 VSS.n90 0.0755
R1267 VSS.n138 VSS.n90 0.0755
R1268 VSS.n138 VSS.n137 0.0755
R1269 VSS.n137 VSS.n136 0.0755
R1270 VSS.n136 VSS.n100 0.0755
R1271 VSS.n132 VSS.n100 0.0755
R1272 VSS.n132 VSS.n131 0.0755
R1273 VSS.n131 VSS.n130 0.0755
R1274 VSS.n130 VSS.n112 0.0755
R1275 VSS.n127 VSS.n113 0.0755
R1276 VSS.n123 VSS.n113 0.0755
R1277 VSS.n366 VSS.n8 0.0755
R1278 VSS.n370 VSS.n8 0.0755
R1279 VSS.n246 VSS.n0 0.0755
R1280 VSS.n351 VSS.n350 0.073625
R1281 VSS.n324 VSS.n323 0.0723125
R1282 VSS.n148 VSS.n79 0.071375
R1283 VSS.n98 VSS.n97 0.070625
R1284 VSS.n168 VSS.n167 0.06875
R1285 VSS.n200 VSS.n53 0.06875
R1286 VSS.n292 VSS.n291 0.06875
R1287 VSS.n283 VSS.n282 0.06875
R1288 VSS.n274 VSS.n273 0.06875
R1289 VSS.n106 VSS.n105 0.068375
R1290 VSS.n152 VSS.n74 0.0670625
R1291 VSS.n343 VSS.n339 0.0648125
R1292 VSS.n122 VSS.n121 0.062
R1293 VSS.n319 VSS.n33 0.062
R1294 VSS.n318 VSS.n34 0.062
R1295 VSS.n315 VSS.n314 0.062
R1296 VSS.n38 VSS.n37 0.062
R1297 VSS.n325 VSS.n29 0.062
R1298 VSS.n326 VSS.n27 0.062
R1299 VSS.n329 VSS.n328 0.062
R1300 VSS.n111 VSS.n110 0.061625
R1301 VSS.n93 VSS.n89 0.059375
R1302 VSS.n154 VSS.n153 0.059
R1303 VSS.n86 VSS.n85 0.058625
R1304 VSS.n329 VSS.n25 0.0575
R1305 VSS.n333 VSS.n332 0.0575
R1306 VSS.n336 VSS.n24 0.0575
R1307 VSS.n337 VSS.n22 0.0575
R1308 VSS.n345 VSS.n344 0.0575
R1309 VSS.n348 VSS.n20 0.0575
R1310 VSS.n349 VSS.n16 0.0575
R1311 VSS.n355 VSS.n354 0.0575
R1312 VSS.n358 VSS.n14 0.0575
R1313 VSS.n359 VSS.n12 0.0575
R1314 VSS.n363 VSS.n362 0.0575
R1315 VSS.n365 VSS.n10 0.0575
R1316 VSS.n360 VSS.n13 0.0569375
R1317 VSS VSS.n0 0.054875
R1318 VSS.n157 VSS.n73 0.0546875
R1319 VSS.n161 VSS.n160 0.0546875
R1320 VSS.n164 VSS.n71 0.0546875
R1321 VSS.n165 VSS.n68 0.0546875
R1322 VSS.n170 VSS.n169 0.0546875
R1323 VSS.n173 VSS.n66 0.0546875
R1324 VSS.n174 VSS.n64 0.0546875
R1325 VSS.n179 VSS.n178 0.0546875
R1326 VSS.n182 VSS.n62 0.0546875
R1327 VSS.n183 VSS.n60 0.0546875
R1328 VSS.n187 VSS.n186 0.0546875
R1329 VSS.n190 VSS.n58 0.0546875
R1330 VSS.n191 VSS.n56 0.0546875
R1331 VSS.n196 VSS.n195 0.0546875
R1332 VSS.n198 VSS.n54 0.0546875
R1333 VSS.n341 VSS.n19 0.052625
R1334 VSS.n309 VSS.n44 0.051875
R1335 VSS.n321 VSS.n31 0.051875
R1336 VSS.n313 VSS.n312 0.051875
R1337 VSS.n202 VSS.n52 0.0513125
R1338 VSS.n312 VSS.n311 0.0507415
R1339 VSS.n150 VSS.n149 0.050375
R1340 VSS.n115 VSS.n99 0.049625
R1341 VSS.n371 VSS.n7 0.04925
R1342 VSS.n374 VSS.n373 0.04925
R1343 VSS.n377 VSS.n5 0.04925
R1344 VSS.n378 VSS.n3 0.04925
R1345 VSS.n203 VSS.n51 0.04925
R1346 VSS.n206 VSS.n205 0.04925
R1347 VSS.n209 VSS.n49 0.04925
R1348 VSS.n211 VSS.n210 0.04925
R1349 VSS.n307 VSS.n46 0.04925
R1350 VSS.n306 VSS.n47 0.04925
R1351 VSS.n303 VSS.n302 0.04925
R1352 VSS.n299 VSS.n215 0.04925
R1353 VSS.n298 VSS.n217 0.04925
R1354 VSS.n295 VSS.n294 0.04925
R1355 VSS.n290 VSS.n219 0.04925
R1356 VSS.n289 VSS.n222 0.04925
R1357 VSS.n286 VSS.n285 0.04925
R1358 VSS.n281 VSS.n224 0.04925
R1359 VSS.n280 VSS.n229 0.04925
R1360 VSS.n277 VSS.n276 0.04925
R1361 VSS.n272 VSS.n231 0.04925
R1362 VSS.n271 VSS.n234 0.04925
R1363 VSS.n268 VSS.n267 0.04925
R1364 VSS.n264 VSS.n236 0.04925
R1365 VSS.n263 VSS.n238 0.04925
R1366 VSS.n260 VSS.n259 0.04925
R1367 VSS.n256 VSS.n240 0.04925
R1368 VSS.n255 VSS.n242 0.04925
R1369 VSS.n252 VSS.n251 0.04925
R1370 VSS.n248 VSS.n244 0.04925
R1371 VSS.n247 VSS.n246 0.04925
R1372 VSS.n104 VSS.n99 0.047375
R1373 VSS.n151 VSS.n150 0.046625
R1374 VSS.n176 VSS.n61 0.04475
R1375 VSS.n291 VSS.n221 0.04475
R1376 VSS.n282 VSS.n228 0.04475
R1377 VSS.n342 VSS.n341 0.044375
R1378 VSS.n120 VSS.n119 0.0411875
R1379 VSS.n147 VSS.n146 0.0385
R1380 VSS.n128 VSS.n127 0.0385
R1381 VSS.n88 VSS.n86 0.038375
R1382 VSS.n89 VSS.n88 0.037625
R1383 VSS.n146 VSS.n80 0.0367143
R1384 VSS.n128 VSS.n112 0.0367143
R1385 VSS.n343 VSS.n342 0.031625
R1386 VSS.n184 VSS.n61 0.03125
R1387 VSS.n225 VSS.n221 0.03125
R1388 VSS.n232 VSS.n228 0.03125
R1389 VSS.n118 VSS.n111 0.030875
R1390 VSS.n152 VSS.n151 0.029375
R1391 VSS.n105 VSS.n104 0.028625
R1392 VSS.n371 VSS.n370 0.02675
R1393 VSS.n373 VSS.n7 0.02675
R1394 VSS.n374 VSS.n5 0.02675
R1395 VSS.n378 VSS.n377 0.02675
R1396 VSS.n380 VSS.n3 0.02675
R1397 VSS.n203 VSS.n202 0.02675
R1398 VSS.n205 VSS.n51 0.02675
R1399 VSS.n206 VSS.n49 0.02675
R1400 VSS.n211 VSS.n209 0.02675
R1401 VSS.n210 VSS.n46 0.02675
R1402 VSS.n307 VSS.n306 0.02675
R1403 VSS.n303 VSS.n47 0.02675
R1404 VSS.n302 VSS.n215 0.02675
R1405 VSS.n299 VSS.n298 0.02675
R1406 VSS.n295 VSS.n217 0.02675
R1407 VSS.n294 VSS.n219 0.02675
R1408 VSS.n290 VSS.n289 0.02675
R1409 VSS.n286 VSS.n222 0.02675
R1410 VSS.n285 VSS.n224 0.02675
R1411 VSS.n281 VSS.n280 0.02675
R1412 VSS.n277 VSS.n229 0.02675
R1413 VSS.n276 VSS.n231 0.02675
R1414 VSS.n272 VSS.n271 0.02675
R1415 VSS.n268 VSS.n234 0.02675
R1416 VSS.n267 VSS.n236 0.02675
R1417 VSS.n264 VSS.n263 0.02675
R1418 VSS.n260 VSS.n238 0.02675
R1419 VSS.n259 VSS.n240 0.02675
R1420 VSS.n256 VSS.n255 0.02675
R1421 VSS.n252 VSS.n242 0.02675
R1422 VSS.n251 VSS.n244 0.02675
R1423 VSS.n248 VSS.n247 0.02675
R1424 VSS.n149 VSS.n148 0.025625
R1425 VSS.n199 VSS.n52 0.0246875
R1426 VSS.n309 VSS.n308 0.024125
R1427 VSS.n321 VSS.n320 0.024125
R1428 VSS.n312 VSS.n30 0.024125
R1429 VSS.n350 VSS.n19 0.023375
R1430 VSS.n157 VSS.n156 0.0213125
R1431 VSS.n160 VSS.n73 0.0213125
R1432 VSS.n161 VSS.n71 0.0213125
R1433 VSS.n165 VSS.n164 0.0213125
R1434 VSS.n169 VSS.n68 0.0213125
R1435 VSS.n170 VSS.n66 0.0213125
R1436 VSS.n174 VSS.n173 0.0213125
R1437 VSS.n178 VSS.n64 0.0213125
R1438 VSS.n179 VSS.n62 0.0213125
R1439 VSS.n183 VSS.n182 0.0213125
R1440 VSS.n186 VSS.n60 0.0213125
R1441 VSS.n187 VSS.n58 0.0213125
R1442 VSS.n191 VSS.n190 0.0213125
R1443 VSS.n195 VSS.n56 0.0213125
R1444 VSS.n196 VSS.n54 0.0213125
R1445 VSS.n199 VSS.n198 0.0213125
R1446 VSS.n352 VSS.n13 0.0190625
R1447 VSS.n332 VSS.n25 0.0185
R1448 VSS.n333 VSS.n24 0.0185
R1449 VSS.n337 VSS.n336 0.0185
R1450 VSS.n344 VSS.n22 0.0185
R1451 VSS.n345 VSS.n20 0.0185
R1452 VSS.n349 VSS.n348 0.0185
R1453 VSS.n354 VSS.n16 0.0185
R1454 VSS.n355 VSS.n14 0.0185
R1455 VSS.n359 VSS.n358 0.0185
R1456 VSS.n362 VSS.n12 0.0185
R1457 VSS.n363 VSS.n10 0.0185
R1458 VSS.n366 VSS.n365 0.0185
R1459 VSS.n85 VSS.n83 0.017375
R1460 VSS VSS.n382 0.017375
R1461 VSS.n94 VSS.n93 0.016625
R1462 VSS.n116 VSS.n115 0.0164375
R1463 VSS.n110 VSS.n108 0.014375
R1464 VSS.n123 VSS.n122 0.014
R1465 VSS.n121 VSS.n33 0.014
R1466 VSS.n319 VSS.n318 0.014
R1467 VSS.n315 VSS.n34 0.014
R1468 VSS.n314 VSS.n38 0.014
R1469 VSS.n37 VSS.n29 0.014
R1470 VSS.n326 VSS.n325 0.014
R1471 VSS.n328 VSS.n27 0.014
R1472 VSS.n339 VSS.n338 0.0111875
R1473 VSS.n116 VSS.n98 0.0104375
R1474 VSS.n107 VSS.n106 0.007625
R1475 VSS.n167 VSS.n166 0.00725
R1476 VSS.n193 VSS.n53 0.00725
R1477 VSS.n293 VSS.n292 0.00725
R1478 VSS.n284 VSS.n283 0.00725
R1479 VSS.n275 VSS.n274 0.00725
R1480 VSS.n97 VSS.n95 0.005375
R1481 VSS.n82 VSS.n79 0.004625
R1482 VSS.n119 VSS.n118 0.0044375
R1483 VSS.n323 VSS.n26 0.0036875
R1484 VSS.n353 VSS.n351 0.002375
C0 outn tail 14.68f
C1 vcm oqn 0.43052f
C2 oip outp 0.20541f
C3 VDD inn 0.23366f
C4 VDD outp 4.50585f
C5 nb x2i_tail 4.33675f
C6 x2i_tail oin 3.92909f
C7 oqn oqp 0.16891f
C8 VDD x2q_tail 0.4423f
C9 nb enb 0.7783f
C10 inn inp 1.82107f
C11 outp inp 6.18554f
C12 nb oin 0.442f
C13 vcm inn 0.20267f
C14 vcm outp 3.3929f
C15 oip VDD 2.03657f
C16 vcm x2q_tail 0.00345f
C17 outn x2i_tail 5.49393f
C18 outp oqp 0.13193f
C19 vt oqn 0.13876f
C20 VDD inp 0.23113f
C21 inn tail 12.2271f
C22 oip vcm 0.18755f
C23 outp tail 14.6174f
C24 nb outn 0.20354f
C25 oqp x2q_tail 4.09819f
C26 outn oin 0.33025f
C27 VDD vcm 1.71588f
C28 vcm inp 0.18531f
C29 VDD oqp 1.5821f
C30 oqn enb 0
C31 nb oqn 2.38722f
C32 VDD tail 0.95652f
C33 vcm oqp 0.24483f
C34 inn x2i_tail 0
C35 tail inp 7.17035f
C36 outp x2i_tail 4.78521f
C37 vcm tail 0.28139f
C38 vt VDD 0.26026f
C39 nb inn 0.09082f
C40 nb outp 0.21791f
C41 outn oqn 0.20838f
C42 outp oin 2.04127f
C43 oip x2i_tail 4.02866f
C44 nb x2q_tail 6.97815f
C45 VDD x2i_tail 0.4499f
C46 vt vcm 0.07779f
C47 VDD enb 0.31951f
C48 oip nb 0.74345f
C49 oip oin 0.59817f
C50 nb VDD 4.58792f
C51 VDD oin 3.9316f
C52 outn inn 5.60588f
C53 x2i_tail inp 0
C54 outp outn 3.9644f
C55 vt oqp 0.0591f
C56 vcm x2i_tail 0.00751f
C57 outn x2q_tail 8.15817f
C58 nb inp 0.18399f
C59 vcm enb 2.73623f
C60 nb vcm 5.49697f
C61 vcm oin 3.39538f
C62 oip outn 5.97421f
C63 outp oqn 4.85285f
C64 VDD outn 1.14358f
C65 enb oqp 4.38691f
C66 nb oqp 0.31636f
C67 oqn x2q_tail 3.85225f
C68 nb tail 7.84139f
C69 outn inp 18.7991f
C70 vcm outn 0.34711f
C71 VDD oqn 4.13169f
C72 outp inn 10.251f
C73 vt enb 0.39792f
C74 outn oqp 8.87468f
C75 outp x2q_tail 7.58097f
C76 nb vt 0.12457f
C77 oqp VSS 1.47044f
C78 oqn VSS 2.84871f
C79 enb VSS 0.788749f
C80 inn VSS 1.03988f
C81 inp VSS 1.41283f
C82 oip VSS 1.75766f
C83 nb VSS 12.0635f
C84 oin VSS 2.35911f
C85 VDD VSS 81.24f
C86 x2q_tail VSS 6.46619f
C87 vt VSS 0.67237f
C88 tail VSS 19.28f
C89 vcm VSS 25.6592f
C90 x2i_tail VSS 6.52016f
C91 outn VSS 9.91838f
C92 outp VSS 9.64338f
C93 VDD.n0 VSS 0.348224f
C94 VDD.n1 VSS 0.0755313f
C95 VDD.n2 VSS 0.0377696f
C96 VDD.n3 VSS 0.172826f
C97 VDD.n4 VSS 0.0377696f
C98 VDD.n5 VSS 0.0755313f
C99 VDD.n6 VSS 0.0468289f
C100 VDD.n7 VSS 0.0755313f
C101 VDD.n8 VSS 0.0377696f
C102 VDD.n9 VSS 0.0755313f
C103 VDD.n10 VSS 0.0377696f
C104 VDD.n11 VSS 0.0755313f
C105 VDD.n12 VSS 0.0377696f
C106 VDD.n13 VSS 0.0755313f
C107 VDD.n14 VSS 0.0377696f
C108 VDD.n15 VSS 0.0755313f
C109 VDD.n16 VSS 0.0377696f
C110 VDD.n17 VSS 0.0755313f
C111 VDD.n18 VSS 0.0377696f
C112 VDD.n19 VSS 0.0755313f
C113 VDD.n20 VSS 0.0377696f
C114 VDD.n21 VSS 0.0404612f
C115 VDD.n22 VSS 0.0400324f
C116 VDD.n23 VSS 0.0377696f
C117 VDD.n24 VSS 0.0755313f
C118 VDD.n25 VSS 0.0377696f
C119 VDD.n26 VSS 0.0755313f
C120 VDD.n27 VSS 0.0377696f
C121 VDD.n28 VSS 0.19998f
C122 VDD.n29 VSS 0.0377696f
C123 VDD.n30 VSS 0.0755313f
C124 VDD.n31 VSS 0.0782308f
C125 VDD.n32 VSS 0.0755313f
C126 VDD.n33 VSS 0.0755313f
C127 VDD.n34 VSS 0.0755313f
C128 VDD.n35 VSS 0.0755313f
C129 VDD.n36 VSS 0.0755313f
C130 VDD.n37 VSS 0.0755313f
C131 VDD.n38 VSS 0.0755313f
C132 VDD.n39 VSS 0.0755313f
C133 VDD.n40 VSS 0.0755313f
C134 VDD.n41 VSS 0.0755313f
C135 VDD.n42 VSS 0.0755313f
C136 VDD.n43 VSS 0.0755313f
C137 VDD.n44 VSS 0.282474f
C138 VDD.n45 VSS 0.0755313f
C139 VDD.n46 VSS 0.180241f
C140 VDD.n47 VSS 0.0755313f
C141 VDD.n48 VSS 0.0377696f
C142 VDD.n49 VSS 0.0755313f
C143 VDD.n50 VSS 0.0377696f
C144 VDD.n51 VSS 0.0755313f
C145 VDD.n52 VSS 0.0377696f
C146 VDD.n53 VSS 0.0755313f
C147 VDD.n54 VSS 0.0377696f
C148 VDD.n55 VSS 0.0755313f
C149 VDD.n56 VSS 0.0377696f
C150 VDD.n57 VSS 0.0755313f
C151 VDD.n58 VSS 0.0377696f
C152 VDD.n59 VSS 0.0755313f
C153 VDD.n60 VSS 0.0377696f
C154 VDD.n61 VSS 0.0755313f
C155 VDD.n62 VSS 0.0377696f
C156 VDD.n63 VSS 0.0755313f
C157 VDD.n64 VSS 0.0377696f
C158 VDD.n65 VSS 0.0755313f
C159 VDD.n66 VSS 0.0377696f
C160 VDD.n67 VSS 0.0755313f
C161 VDD.n68 VSS 0.0377696f
C162 VDD.n69 VSS 0.0755313f
C163 VDD.n70 VSS 0.0377696f
C164 VDD.n71 VSS 0.0755313f
C165 VDD.n72 VSS 0.0377696f
C166 VDD.n73 VSS 0.0755313f
C167 VDD.n74 VSS 0.0377696f
C168 VDD.n75 VSS 0.0755313f
C169 VDD.n76 VSS 0.0377696f
C170 VDD.n77 VSS 0.0755313f
C171 VDD.n78 VSS 0.0377696f
C172 VDD.n79 VSS 0.0755313f
C173 VDD.n80 VSS 0.0377696f
C174 VDD.n81 VSS 0.0755313f
C175 VDD.n82 VSS 0.0377696f
C176 VDD.n83 VSS 0.0755313f
C177 VDD.n84 VSS 0.0377696f
C178 VDD.n85 VSS 0.0755313f
C179 VDD.n86 VSS 0.0377696f
C180 VDD.n87 VSS 0.0755313f
C181 VDD.n88 VSS 0.0377696f
C182 VDD.n89 VSS 0.0755313f
C183 VDD.n90 VSS 0.0377696f
C184 VDD.n91 VSS 0.0755313f
C185 VDD.n92 VSS 0.0377696f
C186 VDD.n93 VSS 0.0755313f
C187 VDD.n94 VSS 0.0377696f
C188 VDD.n95 VSS 0.0755313f
C189 VDD.n96 VSS 0.0377696f
C190 VDD.n97 VSS 0.0755313f
C191 VDD.n98 VSS 0.0377696f
C192 VDD.n99 VSS 0.0755313f
C193 VDD.n100 VSS 0.0377696f
C194 VDD.n101 VSS 0.0755313f
C195 VDD.n102 VSS 0.0377696f
C196 VDD.n103 VSS 0.0404612f
C197 VDD.n104 VSS 0.805992f
C198 VDD.t5 VSS 0.0932211f
C199 VDD.t0 VSS 0.0310525f
C200 VDD.n105 VSS 0.204259f
C201 VDD.n106 VSS 0.0762458f
C202 VDD.n107 VSS 0.0226602f
C203 VDD.n108 VSS 0.248579f
C204 VDD.n109 VSS 0.0755313f
C205 VDD.n110 VSS 0.0377696f
C206 VDD.n111 VSS 0.0377696f
C207 VDD.n112 VSS 0.129482f
C208 VDD.n113 VSS 0.0755313f
C209 VDD.n114 VSS 0.0377696f
C210 VDD.n115 VSS 0.0377696f
C211 VDD.n116 VSS 0.0755313f
C212 VDD.n117 VSS 0.0755313f
C213 VDD.n118 VSS 0.0377696f
C214 VDD.n119 VSS 0.0377696f
C215 VDD.n120 VSS 0.0755313f
C216 VDD.n121 VSS 0.0755313f
C217 VDD.n122 VSS 0.0377696f
C218 VDD.n123 VSS 0.0377696f
C219 VDD.n124 VSS 0.0755313f
C220 VDD.n125 VSS 0.0755313f
C221 VDD.n126 VSS 0.0377696f
C222 VDD.n127 VSS 0.0377696f
C223 VDD.n128 VSS 0.0755313f
C224 VDD.n129 VSS 0.0755313f
C225 VDD.n130 VSS 0.0377696f
C226 VDD.n131 VSS 0.0377696f
C227 VDD.n132 VSS 0.0755313f
C228 VDD.n133 VSS 0.0755313f
C229 VDD.n134 VSS 0.0377696f
C230 VDD.n135 VSS 0.0377696f
C231 VDD.n136 VSS 0.0755313f
C232 VDD.n137 VSS 0.0755313f
C233 VDD.n138 VSS 0.0377696f
C234 VDD.n139 VSS 0.0377696f
C235 VDD.n140 VSS 0.0755313f
C236 VDD.n141 VSS 0.0755313f
C237 VDD.n142 VSS 0.0377696f
C238 VDD.n143 VSS 0.0377696f
C239 VDD.n144 VSS 0.0755313f
C240 VDD.n145 VSS 0.0755313f
C241 VDD.n146 VSS 0.0377696f
C242 VDD.n147 VSS 0.0377696f
C243 VDD.n148 VSS 0.0755313f
C244 VDD.n149 VSS 0.0755313f
C245 VDD.n150 VSS 0.0377696f
C246 VDD.n151 VSS 0.0377696f
C247 VDD.n152 VSS 0.0755313f
C248 VDD.n153 VSS 0.0755313f
C249 VDD.n154 VSS 0.0377696f
C250 VDD.n155 VSS 0.0377696f
C251 VDD.n156 VSS 0.0755313f
C252 VDD.n157 VSS 0.0755313f
C253 VDD.n158 VSS 0.0377696f
C254 VDD.n159 VSS 0.0377696f
C255 VDD.n160 VSS 0.0755313f
C256 VDD.n161 VSS 0.0755313f
C257 VDD.n162 VSS 0.0377696f
C258 VDD.n163 VSS 0.0377696f
C259 VDD.n164 VSS -1.79896f
C260 VDD.n165 VSS -0.78646f
C261 VDD.n166 VSS 0.0377696f
C262 VDD.n167 VSS 0.0377696f
C263 VDD.n168 VSS 0.0755313f
C264 VDD.n169 VSS 0.0755313f
C265 VDD.n170 VSS 0.0377696f
C266 VDD.n171 VSS 0.0377696f
C267 VDD.n172 VSS 0.0755313f
C268 VDD.n173 VSS 0.0755313f
C269 VDD.n174 VSS 0.0377696f
C270 VDD.n175 VSS 0.0377696f
C271 VDD.n176 VSS 0.0755313f
C272 VDD.n177 VSS 0.0755313f
C273 VDD.n178 VSS 0.0377696f
C274 VDD.n179 VSS 0.0377696f
C275 VDD.n180 VSS 0.0755313f
C276 VDD.n181 VSS 0.0755313f
C277 VDD.n182 VSS 0.0377696f
C278 VDD.n183 VSS 0.0377696f
C279 VDD.n184 VSS 0.0755313f
C280 VDD.n185 VSS 0.0755313f
C281 VDD.n186 VSS 0.0377696f
C282 VDD.n187 VSS 0.0377696f
C283 VDD.n188 VSS 0.0755313f
C284 VDD.n189 VSS 0.0755313f
C285 VDD.n190 VSS 0.0377696f
C286 VDD.n191 VSS 0.0377696f
C287 VDD.n192 VSS 0.0755313f
C288 VDD.n193 VSS 0.0755313f
C289 VDD.n194 VSS 0.0377696f
C290 VDD.n195 VSS 0.0377696f
C291 VDD.n196 VSS 0.0755313f
C292 VDD.n197 VSS 0.0755313f
C293 VDD.n198 VSS 0.0377696f
C294 VDD.n199 VSS 0.0377696f
C295 VDD.n200 VSS 0.0755313f
C296 VDD.n201 VSS 0.0755313f
C297 VDD.n202 VSS 0.0377696f
C298 VDD.n203 VSS 0.0377696f
C299 VDD.n204 VSS 0.0755313f
C300 VDD.n205 VSS 0.0755313f
C301 VDD.n206 VSS 0.0377696f
C302 VDD.n207 VSS 0.0377696f
C303 VDD.n208 VSS 0.0755313f
C304 VDD.n209 VSS 0.0755313f
C305 VDD.n210 VSS 0.0377696f
C306 VDD.n211 VSS 0.0377696f
C307 VDD.n212 VSS 0.0755313f
C308 VDD.n213 VSS 0.0755313f
C309 VDD.n214 VSS 0.0377696f
C310 VDD.n215 VSS 0.0377696f
C311 VDD.n216 VSS 0.0755313f
C312 VDD.n217 VSS 0.0755313f
C313 VDD.n218 VSS 0.0377696f
C314 VDD.n219 VSS 0.0377696f
C315 VDD.n220 VSS 0.0755313f
C316 VDD.n221 VSS 0.234946f
C317 VDD.n222 VSS 0.0377696f
C318 VDD.n223 VSS 0.0421444f
C319 VDD.n224 VSS 0.0632563f
C320 VDD.n225 VSS 0.809351f
C321 VDD.n226 VSS 0.0705054f
C322 VDD.n227 VSS 0.217455f
C323 VDD.n228 VSS 0.0755313f
C324 VDD.n229 VSS 0.0709976f
C325 VDD.n230 VSS 0.0755313f
C326 VDD.n231 VSS 0.0755313f
C327 VDD.n232 VSS 0.0755313f
C328 VDD.n233 VSS 0.0755313f
C329 VDD.n234 VSS 0.0755313f
C330 VDD.n235 VSS 0.0755313f
C331 VDD.n236 VSS 0.0755313f
C332 VDD.n237 VSS 0.0755313f
C333 VDD.n238 VSS 0.0755313f
C334 VDD.n239 VSS 0.0755313f
C335 VDD.n240 VSS 0.0755313f
C336 VDD.n241 VSS 0.0755313f
C337 VDD.n242 VSS 0.0755313f
C338 VDD.n243 VSS 0.0755313f
C339 VDD.n244 VSS 0.0755313f
C340 VDD.n245 VSS 0.0755313f
C341 VDD.n246 VSS 0.0755313f
C342 VDD.n247 VSS 0.0755313f
C343 VDD.n248 VSS 0.0755313f
C344 VDD.n249 VSS 0.0755313f
C345 VDD.n250 VSS 0.0755313f
C346 VDD.n251 VSS 0.0755313f
C347 VDD.n252 VSS 0.0755313f
C348 VDD.n253 VSS 0.0755313f
C349 VDD.n254 VSS 0.193255f
C350 VDD.n255 VSS 0.0117668f
C351 VDD.n256 VSS 0.0755313f
C352 VDD.n257 VSS 0.0755313f
C353 VDD.n258 VSS 0.0755313f
C354 VDD.n259 VSS 0.0755313f
C355 VDD.n260 VSS 0.0755313f
C356 VDD.n261 VSS 0.0445661f
C357 VDD.n262 VSS 0.0439865f
C358 VDD.n263 VSS 0.0377696f
C359 VDD.n264 VSS 0.0755313f
C360 VDD.n265 VSS 0.0755313f
C361 VDD.n266 VSS 0.0377696f
C362 VDD.n267 VSS 0.0377696f
C363 VDD.n268 VSS 0.0755313f
C364 VDD.n269 VSS 0.0755313f
C365 VDD.n270 VSS 0.0377696f
C366 VDD.n271 VSS 0.0377696f
C367 VDD.n272 VSS 0.0636375f
C368 VDD.t6 VSS 0.0693065f
C369 VDD.n273 VSS -0.256479f
C370 VDD.t7 VSS 0.0206196f
C371 VDD.n274 VSS 0.0642012f
C372 VDD.n275 VSS 0.0474006f
C373 VDD.n276 VSS 0.0377696f
C374 VDD.n277 VSS 0.0377696f
C375 VDD.n278 VSS 0.0755313f
C376 VDD.n279 VSS 0.129482f
C377 VDD.n280 VSS 0.0377696f
C378 VDD.n281 VSS 0.0377696f
C379 VDD.n282 VSS 0.0755313f
C380 VDD.n283 VSS 0.0755313f
C381 VDD.n284 VSS 0.0596676f
C382 VDD.n285 VSS 0.0418348f
C383 VDD.n286 VSS 0.156819f
C384 VDD.n287 VSS 0.0377696f
C385 VDD.n288 VSS 0.0377696f
C386 VDD.n289 VSS 0.0755313f
C387 VDD.n290 VSS 0.0755313f
C388 VDD.n291 VSS 0.0377696f
C389 VDD.n292 VSS 0.0377696f
C390 VDD.n293 VSS 0.0755313f
C391 VDD.n294 VSS 0.0755313f
C392 VDD.n295 VSS 0.0377696f
C393 VDD.n296 VSS 0.0377696f
C394 VDD.n297 VSS 0.0755313f
C395 VDD.n298 VSS 0.0755313f
C396 VDD.n299 VSS 0.0377696f
C397 VDD.n300 VSS 0.0377696f
C398 VDD.n301 VSS 0.0755313f
C399 VDD.n302 VSS 0.0755313f
C400 VDD.n303 VSS 0.0377696f
C401 VDD.n304 VSS 0.0377696f
C402 VDD.n305 VSS 0.0755313f
C403 VDD.n306 VSS 0.0755313f
C404 VDD.n307 VSS 0.0377696f
C405 VDD.n308 VSS 0.0377696f
C406 VDD.n309 VSS 0.0377696f
C407 VDD.n310 VSS 0.0755313f
C408 VDD.n311 VSS 0.129482f
C409 VDD.n312 VSS 0.0404612f
C410 VDD.n313 VSS 0.0377696f
C411 VDD.n314 VSS 0.0755313f
C412 VDD.n315 VSS 0.0755313f
C413 VDD.n316 VSS 0.0755313f
C414 VDD.n317 VSS 0.0601439f
C415 VDD.t4 VSS 0.0865438f
C416 VDD.t1 VSS 0.0741577f
C417 VDD.n318 VSS 0.120661f
C418 VDD.n319 VSS 0.075039f
C419 VDD.n320 VSS 0.0454156f
C420 VDD.n321 VSS 0.0426288f
C421 VDD.n322 VSS 0.0377696f
C422 VDD.n323 VSS 0.0755313f
C423 VDD.n324 VSS 0.0755313f
C424 VDD.n325 VSS 0.0755313f
C425 VDD.n326 VSS 0.0377696f
C426 VDD.n327 VSS 0.0377696f
C427 VDD.n328 VSS 0.129482f
C428 VDD.n329 VSS 0.0404612f
C429 VDD.n330 VSS 0.0226602f
C430 VDD.t3 VSS 0.108839f
C431 VDD.t2 VSS 0.0401912f
C432 VDD.n331 VSS 0.226856f
C433 VDD.n332 VSS 0.0617875f
C434 VDD.n333 VSS 0.0455109f
C435 VDD.n334 VSS 0.190452f
C436 VDD.n335 VSS 0.0339347f
C437 oin.t6 VSS 0.0858771f
C438 oin.t0 VSS 0.538306f
C439 oin.n0 VSS 0.198423f
C440 oin.t2 VSS 0.101323f
C441 oin.t1 VSS 0.101323f
C442 oin.n1 VSS 0.357637f
C443 oin.n2 VSS 0.0990476f
C444 oin.t4 VSS 0.101323f
C445 oin.t3 VSS 0.101323f
C446 oin.n3 VSS 0.357637f
C447 oin.n4 VSS 0.0990476f
C448 oin.t5 VSS 0.538306f
C449 oin.n5 VSS 0.281734f
C450 nb.t39 VSS 0.171662f
C451 nb.t38 VSS 0.171251f
C452 nb.n0 VSS 0.219158f
C453 nb.t37 VSS 0.171251f
C454 nb.n1 VSS 0.11255f
C455 nb.t36 VSS 0.171251f
C456 nb.n2 VSS 0.11255f
C457 nb.t35 VSS 0.171251f
C458 nb.n3 VSS 0.11255f
C459 nb.t34 VSS 0.171251f
C460 nb.n4 VSS 0.11255f
C461 nb.t33 VSS 0.171251f
C462 nb.n5 VSS 0.11255f
C463 nb.t32 VSS 0.171251f
C464 nb.n6 VSS 0.17073f
C465 nb.t8 VSS 0.173794f
C466 nb.t9 VSS 0.173273f
C467 nb.n7 VSS 0.277495f
C468 nb.t10 VSS 0.173273f
C469 nb.n8 VSS 0.141771f
C470 nb.t11 VSS 0.173273f
C471 nb.n9 VSS 0.141771f
C472 nb.t12 VSS 0.173273f
C473 nb.n10 VSS 0.141771f
C474 nb.t13 VSS 0.173273f
C475 nb.n11 VSS 0.141771f
C476 nb.t14 VSS 0.173273f
C477 nb.n12 VSS 0.141771f
C478 nb.t15 VSS 0.173273f
C479 nb.n13 VSS 0.141771f
C480 nb.t16 VSS 0.173273f
C481 nb.n14 VSS 0.141771f
C482 nb.t17 VSS 0.173273f
C483 nb.n15 VSS 0.141771f
C484 nb.t18 VSS 0.173273f
C485 nb.n16 VSS 0.141771f
C486 nb.t19 VSS 0.173273f
C487 nb.n17 VSS 0.141771f
C488 nb.t20 VSS 0.173273f
C489 nb.n18 VSS 0.141771f
C490 nb.t21 VSS 0.173273f
C491 nb.n19 VSS 0.13616f
C492 nb.t22 VSS 0.173273f
C493 nb.n20 VSS 0.138762f
C494 nb.t23 VSS 0.173273f
C495 nb.n21 VSS 0.141771f
C496 nb.t24 VSS 0.173273f
C497 nb.n22 VSS 0.141771f
C498 nb.t25 VSS 0.173273f
C499 nb.n23 VSS 0.141771f
C500 nb.t26 VSS 0.173273f
C501 nb.n24 VSS 0.141771f
C502 nb.t27 VSS 0.173273f
C503 nb.n25 VSS 0.141771f
C504 nb.t28 VSS 0.173273f
C505 nb.n26 VSS 0.141771f
C506 nb.t29 VSS 0.173273f
C507 nb.n27 VSS 0.141771f
C508 nb.t30 VSS 0.173273f
C509 nb.n28 VSS 0.141771f
C510 nb.t31 VSS 0.173273f
C511 nb.n29 VSS 0.205855f
C512 nb.n30 VSS 0.527934f
C513 nb.t7 VSS 0.174464f
C514 nb.t6 VSS 0.173913f
C515 nb.n31 VSS 0.298647f
C516 nb.t5 VSS 0.173913f
C517 nb.n32 VSS 0.154155f
C518 nb.t4 VSS 0.173913f
C519 nb.n33 VSS 0.154155f
C520 nb.t3 VSS 0.173913f
C521 nb.n34 VSS 0.154155f
C522 nb.t2 VSS 0.173913f
C523 nb.n35 VSS 0.154155f
C524 nb.t1 VSS 0.173913f
C525 nb.n36 VSS 0.154155f
C526 nb.t0 VSS 0.173913f
C527 nb.n37 VSS 0.335039f
C528 nb.n38 VSS 0.22246f
C529 oip.t1 VSS 0.0969022f
C530 oip.t0 VSS 0.0969022f
C531 oip.n0 VSS 0.389378f
C532 oip.t3 VSS 0.0969022f
C533 oip.t2 VSS 0.0969022f
C534 oip.n1 VSS 0.378649f
C535 oip.n2 VSS 0.170747f
C536 oip.t5 VSS 0.0969022f
C537 oip.t4 VSS 0.0969022f
C538 oip.n3 VSS 0.378649f
C539 oip.n4 VSS 0.199514f
C540 oip.t6 VSS 0.0999573f
C541 oip.n5 VSS 0.288179f
C542 inp.t1 VSS 0.111041f
C543 inp.t2 VSS 0.110246f
C544 inp.n0 VSS 0.278226f
C545 inp.t3 VSS 0.110246f
C546 inp.n1 VSS 0.143794f
C547 inp.t4 VSS 0.110246f
C548 inp.n2 VSS 0.143794f
C549 inp.t5 VSS 0.110246f
C550 inp.n3 VSS 0.143794f
C551 inp.t6 VSS 0.110246f
C552 inp.n4 VSS 0.143794f
C553 inp.t7 VSS 0.110246f
C554 inp.n5 VSS 0.143794f
C555 inp.t8 VSS 0.110246f
C556 inp.n6 VSS 0.143794f
C557 inp.t9 VSS 0.110246f
C558 inp.n7 VSS 0.143794f
C559 inp.t10 VSS 0.110246f
C560 inp.n8 VSS 0.143794f
C561 inp.t11 VSS 0.110246f
C562 inp.n9 VSS 0.143794f
C563 inp.t12 VSS 0.110246f
C564 inp.n10 VSS 0.143794f
C565 inp.t13 VSS 0.110246f
C566 inp.n11 VSS 0.112195f
C567 inp.t14 VSS 0.110246f
C568 inp.n12 VSS 0.138845f
C569 inp.t15 VSS 0.110246f
C570 inp.n13 VSS 0.143794f
C571 inp.t16 VSS 0.110246f
C572 inp.n14 VSS 0.143794f
C573 inp.t17 VSS 0.110246f
C574 inp.n15 VSS 0.143794f
C575 inp.t18 VSS 0.110246f
C576 inp.n16 VSS 0.143794f
C577 inp.t19 VSS 0.110246f
C578 inp.n17 VSS 0.143794f
C579 inp.t20 VSS 0.110246f
C580 inp.n18 VSS 0.143794f
C581 inp.t21 VSS 0.110246f
C582 inp.n19 VSS 0.143794f
C583 inp.t22 VSS 0.110246f
C584 inp.n20 VSS 0.143794f
C585 inp.t23 VSS 0.110246f
C586 inp.n21 VSS 0.143794f
C587 inp.t24 VSS 0.110246f
C588 inp.n22 VSS 0.143222f
C589 inp.t0 VSS 0.0483418f
C590 inp.n23 VSS 0.0649728f
C591 inn.t1 VSS 0.097497f
C592 inn.t2 VSS 0.0973465f
C593 inn.n0 VSS 0.18215f
C594 inn.t3 VSS 0.0973465f
C595 inn.n1 VSS 0.105811f
C596 inn.t4 VSS 0.0973465f
C597 inn.n2 VSS 0.105811f
C598 inn.t5 VSS 0.0973465f
C599 inn.n3 VSS 0.105811f
C600 inn.t6 VSS 0.0973465f
C601 inn.n4 VSS 0.105811f
C602 inn.t7 VSS 0.0973465f
C603 inn.n5 VSS 0.105811f
C604 inn.t8 VSS 0.0973465f
C605 inn.n6 VSS 0.105811f
C606 inn.t9 VSS 0.0973465f
C607 inn.n7 VSS 0.105811f
C608 inn.t10 VSS 0.0973465f
C609 inn.n8 VSS 0.105811f
C610 inn.t11 VSS 0.0973465f
C611 inn.n9 VSS 0.105811f
C612 inn.t12 VSS 0.0973465f
C613 inn.n10 VSS 0.104796f
C614 inn.t13 VSS 0.0954638f
C615 inn.n11 VSS 0.0643034f
C616 inn.n12 VSS 0.0127128f
C617 inn.t14 VSS 0.0954589f
C618 inn.t0 VSS 0.0247926f
C619 inn.n13 VSS 0.137366f
C620 inn.n14 VSS 0.0433923f
C621 inn.t15 VSS 0.0973465f
C622 inn.n15 VSS 0.104964f
C623 inn.t16 VSS 0.0973465f
C624 inn.n16 VSS 0.105811f
C625 inn.t17 VSS 0.0973465f
C626 inn.n17 VSS 0.105811f
C627 inn.t18 VSS 0.0973465f
C628 inn.n18 VSS 0.105811f
C629 inn.t19 VSS 0.0973465f
C630 inn.n19 VSS 0.105811f
C631 inn.t20 VSS 0.0973465f
C632 inn.n20 VSS 0.105811f
C633 inn.t21 VSS 0.0973465f
C634 inn.n21 VSS 0.105811f
C635 inn.t22 VSS 0.0973465f
C636 inn.n22 VSS 0.105811f
C637 inn.t23 VSS 0.0973465f
C638 inn.n23 VSS 0.105811f
C639 inn.t24 VSS 0.0973465f
C640 inn.n24 VSS 0.105473f
C641 enb.t0 VSS 0.0426509f
C642 oqn.t6 VSS 0.123639f
C643 oqn.t0 VSS 0.632428f
C644 oqn.n0 VSS 0.246824f
C645 oqn.t2 VSS 0.112955f
C646 oqn.t1 VSS 0.112955f
C647 oqn.n1 VSS 0.430386f
C648 oqn.n2 VSS 0.121651f
C649 oqn.t4 VSS 0.112955f
C650 oqn.t3 VSS 0.112955f
C651 oqn.n3 VSS 0.430386f
C652 oqn.n4 VSS 0.121651f
C653 oqn.t5 VSS 0.632428f
C654 oqn.n5 VSS 0.324681f
C655 oqp.t1 VSS 0.0982488f
C656 oqp.t0 VSS 0.0982488f
C657 oqp.n0 VSS 0.421371f
C658 oqp.t3 VSS 0.0982488f
C659 oqp.t2 VSS 0.0982488f
C660 oqp.n1 VSS 0.40963f
C661 oqp.n2 VSS 0.195483f
C662 oqp.t5 VSS 0.0982488f
C663 oqp.t4 VSS 0.0982488f
C664 oqp.n3 VSS 0.40963f
C665 oqp.n4 VSS 0.231968f
C666 oqp.t6 VSS 0.123396f
C667 oqp.n5 VSS 0.307466f
.ends
