* rx_mix: magic R+C extraction of layout/rx_mix.gds (layout/gen/pex.sh)
* rcfix.py: split-net C to VSS scaled by (S - K) / S on 7 nets (coupling double count removed)
* extracted 2026-11-16T12:08:57+01:00 with magic 8.3.642, mode rc, from rx_mix.gds
.subckt rx_mix VDD VSS rfp rfn bbp bbn lo lob
X0 VSS.t11 bbp.t6 VSS.t11 VSS.t10 nfet_03v3 ad=2.2932p pd=8.75u as=0 ps=0 w=8.19u l=5u
X1 rfp.t0 lob.t2 bbp.t0 VDD.t7 pfet_03v3 ad=8p pd=18u as=4p ps=9u w=8u l=0.28u
X2 rfp.t4 lob.t0 bbn.t2 VSS.t15 nfet_03v3 ad=8p pd=18u as=4p ps=9u w=8u l=0.28u
X3 VSS.t3 bbn.t7 VSS.t3 VSS.t2 nfet_03v3 ad=2.2932p pd=8.75u as=0 ps=0 w=8.19u l=5u
X4 bbp.t4 lo.t2 rfn.t2 VDD.t3 pfet_03v3 ad=4p pd=9u as=4p ps=9u w=8u l=0.28u
X5 bbn.t5 lo.t3 rfp.t5 VDD.t2 pfet_03v3 ad=4p pd=9u as=4p ps=9u w=8u l=0.28u
X6 bbp.t3 lo.t1 rfp.t2 VSS.t12 nfet_03v3 ad=4p pd=9u as=8p ps=18u w=8u l=0.28u
X7 VSS.t9 bbp.t7 VSS.t9 VSS.t8 nfet_03v3 ad=2.2932p pd=8.75u as=0 ps=0 w=8.19u l=5u
X8 rfn.t4 lo.t5 bbp.t5 VDD.t0 pfet_03v3 ad=4p pd=9u as=4p ps=9u w=8u l=0.28u
X9 rfn.t1 lob.t1 bbp.t2 VSS.t14 nfet_03v3 ad=4p pd=9u as=4p ps=9u w=8u l=0.28u
X10 rfn.t5 lob.t3 bbn.t4 VDD.t6 pfet_03v3 ad=4p pd=9u as=4p ps=9u w=8u l=0.28u
X11 VSS.t7 bbp.t8 VSS.t7 VSS.t6 nfet_03v3 ad=3.6855p pd=17.28u as=0 ps=0 w=8.19u l=5u
X12 VSS.t1 bbn.t8 VSS.t1 VSS.t0 nfet_03v3 ad=3.6855p pd=17.28u as=0 ps=0 w=8.19u l=5u
X13 bbn.t0 lo.t0 rfn.t0 VSS.t13 nfet_03v3 ad=4p pd=9u as=4p ps=9u w=8u l=0.28u
X14 VSS.t5 bbn.t6 VSS.t5 VSS.t4 nfet_03v3 ad=2.2932p pd=8.75u as=0 ps=0 w=8.19u l=5u
X15 bbp.t1 lob.t5 rfp.t1 VDD.t4 pfet_03v3 ad=4p pd=9u as=8p ps=18u w=8u l=0.28u
X16 rfp.t3 lo.t4 bbn.t1 VDD.t1 pfet_03v3 ad=4p pd=9u as=4p ps=9u w=8u l=0.28u
X17 bbn.t3 lob.t4 rfn.t3 VDD.t5 pfet_03v3 ad=4p pd=9u as=4p ps=9u w=8u l=0.28u
R0 bbn.n1 bbn.t8 19.8406
R1 bbn.n6 bbn.t7 19.8406
R2 bbn.n7 bbn.t6 19.8406
R3 bbn.n1 bbn.n0 7.9453
R4 bbn.n3 bbn.n2 6.34467
R5 bbn.n5 bbn.n4 6.34467
R6 bbn.n7 bbn.n6 1.31734
R7 bbn bbn.n7 1.05445
R8 bbn.n5 bbn.n3 0.606816
R9 bbn.n2 bbn.t1 0.438
R10 bbn.n2 bbn.t3 0.438
R11 bbn.n4 bbn.t4 0.438
R12 bbn.n4 bbn.t5 0.438
R13 bbn.n0 bbn.t2 0.39425
R14 bbn.n0 bbn.t0 0.39425
R15 bbn.n3 bbn.n1 0.329711
R16 bbn bbn.n5 0.242079
R17 bbn.n6 bbn 0.140237
R18 rfn.n2 rfn.n0 7.39625
R19 rfn.n4 rfn.n3 6.79661
R20 rfn.n2 rfn.n1 6.18362
R21 rfn.n4 rfn.n2 1.63945
R22 rfn rfn.n4 1.11839
R23 rfn.n1 rfn.t3 0.438
R24 rfn.n1 rfn.t4 0.438
R25 rfn.n0 rfn.t2 0.438
R26 rfn.n0 rfn.t5 0.438
R27 rfn.n3 rfn.t0 0.39425
R28 rfn.n3 rfn.t1 0.39425
R29 bbp.n0 bbp.t8 20.8353
R30 bbp.n0 bbp.t7 19.5185
R31 bbp.n1 bbp.t6 19.5185
R32 bbp.n5 bbp.n4 6.66678
R33 bbp.n7 bbp.n6 6.66678
R34 bbp.n3 bbp.n2 6.31346
R35 bbp bbp.n7 2.14629
R36 bbp.n7 bbp.n5 1.81945
R37 bbp.n1 bbp.n0 1.31734
R38 bbp.n3 bbp.n1 1.31024
R39 bbp.n5 bbp 0.821158
R40 bbp bbp.n3 0.81879
R41 bbp.n4 bbp.t5 0.438
R42 bbp.n4 bbp.t1 0.438
R43 bbp.n6 bbp.t0 0.438
R44 bbp.n6 bbp.t4 0.438
R45 bbp.n2 bbp.t2 0.39425
R46 bbp.n2 bbp.t3 0.39425
R47 rfp.n1 rfp.t0 8.47796
R48 rfp.n2 rfp.t1 7.26533
R49 rfp.n1 rfp.n0 6.82783
R50 rfp.n4 rfp.t2 6.54615
R51 rfp.n3 rfp.t4 6.54615
R52 rfp.n2 rfp.n1 1.21313
R53 rfp.n4 rfp.n3 1.21313
R54 rfp.n0 rfp.t5 0.438
R55 rfp.n0 rfp.t3 0.438
R56 rfp.n3 rfp.n2 0.426816
R57 rfp rfp.n4 0.208921
R58 lo.n3 lo.t1 128.855
R59 lo.n3 lo.t0 128.249
R60 lo.n0 lo.t2 127.984
R61 lo.n2 lo.t5 127.379
R62 lo.n1 lo.t4 127.379
R63 lo.n0 lo.t3 127.379
R64 lo lo.n5 4.5005
R65 lo.n4 lo.n3 1.12313
R66 lo.n2 lo.n1 0.606816
R67 lo.n1 lo.n0 0.303658
R68 lo.n5 lo.n2 0.204184
R69 lo.n5 lo.n4 0.00997368
R70 lob.n0 lob.t2 128.468
R71 lob.n2 lob.t1 128.371
R72 lob.n3 lob.t5 127.862
R73 lob.n1 lob.t4 127.862
R74 lob.n0 lob.t3 127.862
R75 lob.n2 lob.t0 127.766
R76 lob lob.n5 4.5005
R77 lob.n1 lob.n0 0.909974
R78 lob.n3 lob.n2 0.729974
R79 lob.n4 lob.n3 0.393658
R80 lob.n5 lob.n1 0.185237
R81 lob.n5 lob.n4 0.0289211
R82 VDD.n14 VDD.t4 2200.74
R83 VDD.t3 VDD.t7 116.047
R84 VDD.t6 VDD.t3 116.047
R85 VDD.t2 VDD.t6 116.047
R86 VDD.t1 VDD.t2 116.047
R87 VDD.t5 VDD.t1 116.047
R88 VDD.t0 VDD.t5 116.047
R89 VDD.t4 VDD.t0 116.047
R90 VDD.n40 VDD.n1 1.57925
R91 VDD.n40 VDD.n39 1.5755
R92 VDD.n39 VDD.n38 1.5005
R93 VDD.n3 VDD.n2 1.5005
R94 VDD.n33 VDD.n32 1.5005
R95 VDD.n31 VDD.n30 1.5005
R96 VDD.n7 VDD.n6 1.5005
R97 VDD.n25 VDD.n24 1.5005
R98 VDD.n23 VDD.n22 1.5005
R99 VDD.n11 VDD.n10 1.5005
R100 VDD.n17 VDD.n16 1.5005
R101 VDD.n13 VDD.n12 1.5005
R102 VDD.n19 VDD.n18 1.5005
R103 VDD.n21 VDD.n20 1.5005
R104 VDD.n9 VDD.n8 1.5005
R105 VDD.n27 VDD.n26 1.5005
R106 VDD.n29 VDD.n28 1.5005
R107 VDD.n5 VDD.n4 1.5005
R108 VDD.n35 VDD.n34 1.5005
R109 VDD.n37 VDD.n36 1.5005
R110 VDD.n1 VDD.n0 1.5005
R111 VDD.n16 VDD.n15 0.590808
R112 VDD.n15 VDD.n14 0.420927
R113 VDD.n19 VDD.n12 0.0755
R114 VDD.n20 VDD.n19 0.0755
R115 VDD.n20 VDD.n8 0.0755
R116 VDD.n27 VDD.n8 0.0755
R117 VDD.n28 VDD.n27 0.0755
R118 VDD.n28 VDD.n4 0.0755
R119 VDD.n35 VDD.n4 0.0755
R120 VDD.n36 VDD.n35 0.0755
R121 VDD.n36 VDD.n1 0.0755
R122 VDD.n16 VDD.n10 0.0755
R123 VDD.n23 VDD.n10 0.0755
R124 VDD.n24 VDD.n23 0.0755
R125 VDD.n24 VDD.n6 0.0755
R126 VDD.n31 VDD.n6 0.0755
R127 VDD.n32 VDD.n31 0.0755
R128 VDD.n32 VDD.n2 0.0755
R129 VDD.n39 VDD.n2 0.0755
R130 VDD.n17 VDD.n13 0.07175
R131 VDD.n18 VDD.n11 0.07175
R132 VDD.n22 VDD.n21 0.07175
R133 VDD.n25 VDD.n9 0.07175
R134 VDD.n26 VDD.n7 0.07175
R135 VDD.n30 VDD.n29 0.07175
R136 VDD.n33 VDD.n5 0.07175
R137 VDD.n34 VDD.n3 0.07175
R138 VDD.n38 VDD.n37 0.07175
R139 VDD.n14 VDD.n12 0.06725
R140 VDD.n15 VDD.n13 0.0667409
R141 VDD VDD.n0 0.054875
R142 VDD VDD.n40 0.017375
R143 VDD.n18 VDD.n17 0.00425
R144 VDD.n21 VDD.n11 0.00425
R145 VDD.n22 VDD.n9 0.00425
R146 VDD.n26 VDD.n25 0.00425
R147 VDD.n29 VDD.n7 0.00425
R148 VDD.n30 VDD.n5 0.00425
R149 VDD.n34 VDD.n33 0.00425
R150 VDD.n37 VDD.n3 0.00425
R151 VDD.n38 VDD.n0 0.00425
R152 VSS.t6 VSS.t4 353285
R153 VSS.t4 VSS.t2 1088.23
R154 VSS.t2 VSS.t0 1088.23
R155 VSS.t0 VSS.t15 860.821
R156 VSS.t10 VSS.t8 688.775
R157 VSS.t8 VSS.t6 688.775
R158 VSS.t12 VSS.t10 605.775
R159 VSS.t15 VSS.t13 158.567
R160 VSS.t14 VSS.t12 158.567
R161 VSS.n59 VSS.t14 128.837
R162 VSS.n59 VSS.t13 29.7318
R163 VSS.n31 VSS.t5 1.68972
R164 VSS.t1 VSS.n18 1.68691
R165 VSS.n69 VSS.t11 1.68691
R166 VSS.t7 VSS.n1 1.68691
R167 VSS.n93 VSS.n92 1.5755
R168 VSS.n31 VSS.n28 1.53671
R169 VSS.n93 VSS.n1 1.52994
R170 VSS.n92 VSS.n91 1.5005
R171 VSS.n3 VSS.n2 1.5005
R172 VSS.n85 VSS.n84 1.5005
R173 VSS.n83 VSS.n82 1.5005
R174 VSS.n7 VSS.n6 1.5005
R175 VSS.n75 VSS.n74 1.5005
R176 VSS.n73 VSS.n72 1.5005
R177 VSS.n13 VSS.n12 1.5005
R178 VSS.n66 VSS.n65 1.5005
R179 VSS.n64 VSS.n63 1.5005
R180 VSS.n17 VSS.n16 1.5005
R181 VSS.n56 VSS.n55 1.5005
R182 VSS.n54 VSS.n53 1.5005
R183 VSS.n21 VSS.n20 1.5005
R184 VSS.n47 VSS.n46 1.5005
R185 VSS.n45 VSS.n44 1.5005
R186 VSS.n25 VSS.n24 1.5005
R187 VSS.n38 VSS.n37 1.5005
R188 VSS.n36 VSS.n35 1.5005
R189 VSS.n34 VSS.n33 1.5005
R190 VSS.n32 VSS.n27 1.5005
R191 VSS.n40 VSS.n39 1.5005
R192 VSS.n43 VSS.n42 1.5005
R193 VSS.n41 VSS.n23 1.5005
R194 VSS.n49 VSS.n48 1.5005
R195 VSS.n52 VSS.n51 1.5005
R196 VSS.n50 VSS.n19 1.5005
R197 VSS.n58 VSS.n57 1.5005
R198 VSS.n62 VSS.n61 1.5005
R199 VSS.n15 VSS.n14 1.5005
R200 VSS.n68 VSS.n67 1.5005
R201 VSS.n71 VSS.n70 1.5005
R202 VSS.n11 VSS.n10 1.5005
R203 VSS.n77 VSS.n76 1.5005
R204 VSS.n81 VSS.n80 1.5005
R205 VSS.n79 VSS.n5 1.5005
R206 VSS.n87 VSS.n86 1.5005
R207 VSS.n90 VSS.n89 1.5005
R208 VSS.n88 VSS.n0 1.5005
R209 VSS.n30 VSS.n26 1.48306
R210 VSS.n29 VSS.n22 1.48306
R211 VSS.n78 VSS.n9 1.48306
R212 VSS.n8 VSS.n4 1.48306
R213 VSS.n36 VSS.n28 0.827786
R214 VSS.t5 VSS.n30 0.215885
R215 VSS.n30 VSS.t3 0.215885
R216 VSS.t3 VSS.n29 0.215885
R217 VSS.n29 VSS.t1 0.215885
R218 VSS.t11 VSS.n9 0.215885
R219 VSS.n9 VSS.t9 0.215885
R220 VSS.t9 VSS.n8 0.215885
R221 VSS.n8 VSS.t7 0.215885
R222 VSS.n60 VSS.n59 0.112328
R223 VSS.n33 VSS.n31 0.0755
R224 VSS.n33 VSS.n32 0.0755
R225 VSS.n42 VSS.n40 0.0755
R226 VSS.n42 VSS.n41 0.0755
R227 VSS.n51 VSS.n49 0.0755
R228 VSS.n51 VSS.n50 0.0755
R229 VSS.n61 VSS.n58 0.0755
R230 VSS.n68 VSS.n14 0.0755
R231 VSS.n70 VSS.n10 0.0755
R232 VSS.n77 VSS.n10 0.0755
R233 VSS.n80 VSS.n79 0.0755
R234 VSS.n89 VSS.n87 0.0755
R235 VSS.n89 VSS.n88 0.0755
R236 VSS.n37 VSS.n36 0.0755
R237 VSS.n37 VSS.n24 0.0755
R238 VSS.n45 VSS.n24 0.0755
R239 VSS.n46 VSS.n45 0.0755
R240 VSS.n46 VSS.n20 0.0755
R241 VSS.n54 VSS.n20 0.0755
R242 VSS.n55 VSS.n54 0.0755
R243 VSS.n55 VSS.n16 0.0755
R244 VSS.n64 VSS.n16 0.0755
R245 VSS.n65 VSS.n64 0.0755
R246 VSS.n65 VSS.n12 0.0755
R247 VSS.n73 VSS.n12 0.0755
R248 VSS.n74 VSS.n73 0.0755
R249 VSS.n74 VSS.n6 0.0755
R250 VSS.n83 VSS.n6 0.0755
R251 VSS.n84 VSS.n83 0.0755
R252 VSS.n84 VSS.n2 0.0755
R253 VSS.n92 VSS.n2 0.0755
R254 VSS.n35 VSS.n34 0.07175
R255 VSS.n38 VSS.n27 0.07175
R256 VSS.n39 VSS.n25 0.07175
R257 VSS.n44 VSS.n43 0.07175
R258 VSS.n47 VSS.n23 0.07175
R259 VSS.n48 VSS.n21 0.07175
R260 VSS.n53 VSS.n52 0.07175
R261 VSS.n56 VSS.n19 0.07175
R262 VSS.n57 VSS.n17 0.07175
R263 VSS.n63 VSS.n62 0.07175
R264 VSS.n66 VSS.n15 0.07175
R265 VSS.n67 VSS.n13 0.07175
R266 VSS.n72 VSS.n71 0.07175
R267 VSS.n75 VSS.n11 0.07175
R268 VSS.n76 VSS.n7 0.07175
R269 VSS.n82 VSS.n81 0.07175
R270 VSS.n85 VSS.n5 0.07175
R271 VSS.n86 VSS.n3 0.07175
R272 VSS.n91 VSS.n90 0.07175
R273 VSS.n80 VSS.n78 0.067625
R274 VSS.n60 VSS.n14 0.06725
R275 VSS.n79 VSS.n4 0.066875
R276 VSS.n32 VSS.n26 0.055625
R277 VSS VSS.n0 0.054875
R278 VSS.n58 VSS.n18 0.0539375
R279 VSS.n70 VSS.n69 0.0505625
R280 VSS.n88 VSS.n1 0.0498125
R281 VSS.n41 VSS.n22 0.039125
R282 VSS.n34 VSS.n28 0.0386786
R283 VSS.n49 VSS.n22 0.036875
R284 VSS.n69 VSS.n68 0.0254375
R285 VSS.n50 VSS.n18 0.0220625
R286 VSS.n40 VSS.n26 0.020375
R287 VSS VSS.n93 0.017375
R288 VSS.n87 VSS.n4 0.009125
R289 VSS.n61 VSS.n60 0.00875
R290 VSS.n78 VSS.n77 0.008375
R291 VSS.n35 VSS.n27 0.00425
R292 VSS.n39 VSS.n38 0.00425
R293 VSS.n43 VSS.n25 0.00425
R294 VSS.n44 VSS.n23 0.00425
R295 VSS.n48 VSS.n47 0.00425
R296 VSS.n52 VSS.n21 0.00425
R297 VSS.n53 VSS.n19 0.00425
R298 VSS.n57 VSS.n56 0.00425
R299 VSS.n62 VSS.n17 0.00425
R300 VSS.n63 VSS.n15 0.00425
R301 VSS.n67 VSS.n66 0.00425
R302 VSS.n71 VSS.n13 0.00425
R303 VSS.n72 VSS.n11 0.00425
R304 VSS.n76 VSS.n75 0.00425
R305 VSS.n81 VSS.n7 0.00425
R306 VSS.n82 VSS.n5 0.00425
R307 VSS.n86 VSS.n85 0.00425
R308 VSS.n90 VSS.n3 0.00425
R309 VSS.n91 VSS.n0 0.00425
C0 rfp bbn 2.1618f
C1 rfp lo 1.10179f
C2 rfn lob 1.70994f
C3 bbp VDD 0.19111f
C4 rfn rfp 0.17104f
C5 bbp bbn 0.87336f
C6 bbn VDD 0.23335f
C7 bbp lo 1.20493f
C8 lo VDD 0.89717f
C9 bbn lo 1.39957f
C10 rfp lob 1.89273f
C11 rfn bbp 1.93204f
C12 rfn VDD 0.19111f
C13 rfn bbn 2.45457f
C14 rfn lo 2.83249f
C15 bbp lob 3.22561f
C16 lob VDD 0.86817f
C17 lob bbn 3.31244f
C18 lob lo 0.95116f
C19 bbp rfp 4.92845f
C20 rfp VDD 0.44635f
C21 bbn VSS 3.31568f
C22 rfn VSS 0.359224f
C23 bbp VSS 3.13625f
C24 rfp VSS 0.90741f
C25 lo VSS 0.450263f
C26 lob VSS 0.29896f
C27 VDD VSS 28.2204f
C28 VDD.n0 VSS 0.0104964f
C29 VDD.n1 VSS 0.045173f
C30 VDD.n2 VSS 0.0270928f
C31 VDD.n3 VSS 0.0135464f
C32 VDD.n4 VSS 0.0270928f
C33 VDD.n5 VSS 0.0135464f
C34 VDD.n6 VSS 0.0270928f
C35 VDD.n7 VSS 0.0135464f
C36 VDD.n8 VSS 0.0270928f
C37 VDD.n9 VSS 0.0135464f
C38 VDD.n10 VSS 0.0270928f
C39 VDD.n11 VSS 0.0135464f
C40 VDD.n12 VSS 0.0255999f
C41 VDD.n13 VSS 0.0335958f
C42 VDD.t7 VSS 0.0949897f
C43 VDD.t3 VSS 0.0796939f
C44 VDD.t6 VSS 0.0796939f
C45 VDD.t2 VSS 0.0796939f
C46 VDD.t1 VSS 0.0796939f
C47 VDD.t5 VSS 0.0796939f
C48 VDD.t0 VSS 0.0796939f
C49 VDD.t4 VSS 0.15479f
C50 VDD.n14 VSS 0.491691f
C51 VDD.n15 VSS 0.439237f
C52 VDD.n16 VSS 0.108133f
C53 VDD.n17 VSS 0.0135464f
C54 VDD.n18 VSS 0.0135464f
C55 VDD.n19 VSS 0.0270928f
C56 VDD.n20 VSS 0.0270928f
C57 VDD.n21 VSS 0.0135464f
C58 VDD.n22 VSS 0.0135464f
C59 VDD.n23 VSS 0.0270928f
C60 VDD.n24 VSS 0.0270928f
C61 VDD.n25 VSS 0.0135464f
C62 VDD.n26 VSS 0.0135464f
C63 VDD.n27 VSS 0.0270928f
C64 VDD.n28 VSS 0.0270928f
C65 VDD.n29 VSS 0.0135464f
C66 VDD.n30 VSS 0.0135464f
C67 VDD.n31 VSS 0.0270928f
C68 VDD.n32 VSS 0.0270928f
C69 VDD.n33 VSS 0.0135464f
C70 VDD.n34 VSS 0.0135464f
C71 VDD.n35 VSS 0.0270928f
C72 VDD.n36 VSS 0.0270928f
C73 VDD.n37 VSS 0.0135464f
C74 VDD.n38 VSS 0.0135464f
C75 VDD.n39 VSS 0.0464461f
C76 VDD.n40 VSS 0.0116779f
C77 lob.t2 VSS 0.0616323f
C78 lob.t3 VSS 0.0612549f
C79 lob.n0 VSS 0.181979f
C80 lob.t4 VSS 0.0612549f
C81 lob.n1 VSS 0.0908531f
C82 lob.t1 VSS 0.0613813f
C83 lob.t0 VSS 0.061027f
C84 lob.n2 VSS 0.166984f
C85 lob.t5 VSS 0.0612549f
C86 lob.n3 VSS 0.0916337f
C87 lob.n4 VSS 0.0115736f
C88 lob.n5 VSS 0.00585137f
C89 lo.t2 VSS 0.0775694f
C90 lo.t3 VSS 0.0772371f
C91 lo.n0 VSS 0.147183f
C92 lo.t4 VSS 0.0772371f
C93 lo.n1 VSS 0.0775146f
C94 lo.t5 VSS 0.0772371f
C95 lo.n2 VSS 0.0740076f
C96 lo.t1 VSS 0.0804916f
C97 lo.t0 VSS 0.0798865f
C98 lo.n3 VSS 0.293239f
C99 lo.n4 VSS 0.0399103f
C100 lo.n5 VSS 0.00751395f
C101 rfp.t0 VSS 0.373f
C102 rfp.t5 VSS 0.0629583f
C103 rfp.t3 VSS 0.0629583f
C104 rfp.n0 VSS 0.255583f
C105 rfp.n1 VSS 0.14786f
C106 rfp.t1 VSS 0.362317f
C107 rfp.n2 VSS 0.0831805f
C108 rfp.t4 VSS 0.335172f
C109 rfp.n3 VSS 0.0729458f
C110 rfp.t2 VSS 0.335172f
C111 rfp.n4 VSS 0.0674432f
C112 bbp.t8 VSS 1.02863f
C113 bbp.t7 VSS 1.01891f
C114 bbp.n0 VSS 0.323605f
C115 bbp.t6 VSS 1.01891f
C116 bbp.n1 VSS 0.179382f
C117 bbp.t2 VSS 0.052295f
C118 bbp.t3 VSS 0.052295f
C119 bbp.n2 VSS 0.193447f
C120 bbp.n3 VSS 0.0579824f
C121 bbp.t5 VSS 0.052295f
C122 bbp.t1 VSS 0.052295f
C123 bbp.n4 VSS 0.207415f
C124 bbp.n5 VSS 0.0722808f
C125 bbp.t0 VSS 0.052295f
C126 bbp.t4 VSS 0.052295f
C127 bbp.n6 VSS 0.207415f
C128 bbp.n7 VSS 0.10008f
C129 rfn.t2 VSS 0.0488805f
C130 rfn.t5 VSS 0.0488805f
C131 rfn.n0 VSS 0.18571f
C132 rfn.t3 VSS 0.0488805f
C133 rfn.t4 VSS 0.0488805f
C134 rfn.n1 VSS 0.179718f
C135 rfn.n2 VSS 0.0974696f
C136 rfn.t0 VSS 0.0488805f
C137 rfn.t1 VSS 0.0488805f
C138 rfn.n3 VSS 0.194787f
C139 rfn.n4 VSS 0.0714889f
C140 bbn.t2 VSS 0.0500317f
C141 bbn.t0 VSS 0.0500317f
C142 bbn.n0 VSS 0.20196f
C143 bbn.t8 VSS 0.979703f
C144 bbn.n1 VSS 0.196669f
C145 bbn.t1 VSS 0.0500317f
C146 bbn.t3 VSS 0.0500317f
C147 bbn.n2 VSS 0.188855f
C148 bbn.n3 VSS 0.0315978f
C149 bbn.t4 VSS 0.0500317f
C150 bbn.t5 VSS 0.0500317f
C151 bbn.n4 VSS 0.188855f
C152 bbn.n5 VSS 0.029837f
C153 bbn.t7 VSS 0.979703f
C154 bbn.n6 VSS 0.156122f
C155 bbn.t6 VSS 0.979703f
C156 bbn.n7 VSS 0.174466f
.ends
