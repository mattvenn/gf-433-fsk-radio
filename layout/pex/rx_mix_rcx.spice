* rx_mix: magic R+C extraction of layout/rx_mix.gds (layout/gen/pex.sh)
* rcfix.py: split-net C to VSS scaled by (S - K) / S on 7 nets (coupling double count removed)
* extracted 2026-11-15T23:54:28+01:00 with magic 8.3.642, mode rc, from rx_mix.gds
.subckt rx_mix VDD VSS rfp rfn bbp bbn lo lob
X0 VSS.t11 bbp.t4 VSS.t11 VSS.t10 nfet_03v3 ad=2.2932p pd=8.75u as=0 ps=0 w=8.19u l=5u
X1 rfp.t0 lob.t0 bbn.t0 VSS.t15 nfet_03v3 ad=8p pd=18u as=4p ps=9u w=8u l=0.28u
X2 bbp.t3 lo.t1 rfp.t3 VSS.t12 nfet_03v3 ad=4p pd=9u as=8p ps=18u w=8u l=0.28u
X3 VSS.t1 bbn.t6 VSS.t1 VSS.t0 nfet_03v3 ad=3.6855p pd=17.28u as=0 ps=0 w=8.19u l=5u
X4 VSS.t9 bbp.t5 VSS.t9 VSS.t8 nfet_03v3 ad=2.2932p pd=8.75u as=0 ps=0 w=8.19u l=5u
X5 rfn.t1 lo.t3 bbp.t1 VDD.t0 pfet_03v3 ad=8p pd=17u as=8p ps=17u w=16u l=0.28u
X6 rfn.t0 lob.t1 bbp.t0 VSS.t14 nfet_03v3 ad=4p pd=9u as=4p ps=9u w=8u l=0.28u
X7 VSS.t5 bbn.t4 VSS.t5 VSS.t4 nfet_03v3 ad=2.2932p pd=8.75u as=0 ps=0 w=8.19u l=5u
X8 VSS.t7 bbp.t6 VSS.t7 VSS.t6 nfet_03v3 ad=3.6855p pd=17.28u as=0 ps=0 w=8.19u l=5u
X9 bbn.t2 lo.t0 rfn.t2 VSS.t13 nfet_03v3 ad=4p pd=9u as=4p ps=9u w=8u l=0.28u
X10 bbp.t2 lob.t3 rfp.t2 VDD.t2 pfet_03v3 ad=8p pd=17u as=16p ps=34u w=16u l=0.28u
X11 rfp.t1 lo.t2 bbn.t1 VDD.t1 pfet_03v3 ad=16p pd=34u as=8p ps=17u w=16u l=0.28u
X12 VSS.t3 bbn.t5 VSS.t3 VSS.t2 nfet_03v3 ad=2.2932p pd=8.75u as=0 ps=0 w=8.19u l=5u
X13 bbn.t3 lob.t2 rfn.t3 VDD.t3 pfet_03v3 ad=8p pd=17u as=8p ps=17u w=16u l=0.28u
R0 bbn.n3 bbn.t6 20.1627
R1 bbn.n4 bbn.t5 20.1627
R2 bbn.n5 bbn.t4 20.1627
R3 bbn.n2 bbn.n0 8.59661
R4 bbn.n2 bbn.n1 6.81699
R5 bbn.n5 bbn.n4 1.31734
R6 bbn.n3 bbn.n2 1.31024
R7 bbn bbn.n5 1.05445
R8 bbn.n4 bbn 0.959711
R9 bbn.n0 bbn.t0 0.39425
R10 bbn.n0 bbn.t2 0.39425
R11 bbn bbn.n3 0.358132
R12 bbn.n1 bbn.t1 0.21925
R13 bbn.n1 bbn.t3 0.21925
R14 rfn.n2 rfn.n0 9.10015
R15 rfn.n2 rfn.n1 6.31346
R16 rfn rfn.n2 1.72471
R17 rfn.n1 rfn.t2 0.39425
R18 rfn.n1 rfn.t0 0.39425
R19 rfn.n0 rfn.t3 0.21925
R20 rfn.n0 rfn.t1 0.21925
R21 bbp.n0 bbp.t6 20.9964
R22 bbp.n0 bbp.t5 19.6796
R23 bbp.n1 bbp.t4 19.6796
R24 bbp.n3 bbp.n2 6.47451
R25 bbp bbp.n6 5.60418
R26 bbp.n6 bbp.n5 4.5005
R27 bbp.n5 bbp.n4 2.80015
R28 bbp bbp.n3 1.63826
R29 bbp.n1 bbp.n0 1.31734
R30 bbp.n3 bbp.n1 1.31024
R31 bbp.n2 bbp.t0 0.39425
R32 bbp.n2 bbp.t3 0.39425
R33 bbp.n4 bbp.t1 0.21925
R34 bbp.n4 bbp.t2 0.21925
R35 bbp.n6 bbp 0.00168421
R36 rfp.n0 rfp.t1 9.05364
R37 rfp.n0 rfp.t2 7.84101
R38 rfp.n2 rfp.t3 6.54615
R39 rfp.n1 rfp.t0 6.54615
R40 rfp.n2 rfp.n1 1.21313
R41 rfp rfp.n2 0.815237
R42 rfp.n1 rfp.n0 0.426816
R43 lo.n0 lo.t2 232.593
R44 lo.n0 lo.t3 231.987
R45 lo.n2 lo.t1 128.532
R46 lo.n2 lo.t0 127.927
R47 lo lo.n3 4.5005
R48 lo.n1 lo.n0 0.668395
R49 lo.n3 lo.n2 0.649447
R50 lo.n3 lo.n1 0.0194474
R51 lob.n0 lob.t2 232.431
R52 lob.n0 lob.t3 231.825
R53 lob.n1 lob.t1 128.694
R54 lob.n1 lob.t0 128.088
R55 lob lob.n2 9.37116
R56 lob lob.n1 0.365237
R57 lob.n2 lob 0.303658
R58 lob.n2 lob.n0 0.0620789
R59 VDD.t3 VDD.t1 67.2627
R60 VDD.t0 VDD.t3 67.2627
R61 VDD.t2 VDD.t0 67.2627
R62 VDD.n15 VDD.t2 60.0345
R63 VDD.n44 VDD.n1 1.57925
R64 VDD.n19 VDD.n14 1.5755
R65 VDD.n44 VDD.n43 1.5755
R66 VDD.n43 VDD.n42 1.5005
R67 VDD.n3 VDD.n2 1.5005
R68 VDD.n37 VDD.n36 1.5005
R69 VDD.n35 VDD.n34 1.5005
R70 VDD.n7 VDD.n6 1.5005
R71 VDD.n29 VDD.n28 1.5005
R72 VDD.n27 VDD.n26 1.5005
R73 VDD.n11 VDD.n10 1.5005
R74 VDD.n21 VDD.n20 1.5005
R75 VDD.n19 VDD.n18 1.5005
R76 VDD.n17 VDD.n16 1.5005
R77 VDD.n13 VDD.n12 1.5005
R78 VDD.n23 VDD.n22 1.5005
R79 VDD.n25 VDD.n24 1.5005
R80 VDD.n9 VDD.n8 1.5005
R81 VDD.n31 VDD.n30 1.5005
R82 VDD.n33 VDD.n32 1.5005
R83 VDD.n5 VDD.n4 1.5005
R84 VDD.n39 VDD.n38 1.5005
R85 VDD.n41 VDD.n40 1.5005
R86 VDD.n1 VDD.n0 1.5005
R87 VDD.n15 VDD.n14 0.43943
R88 VDD.n16 VDD.n15 0.110061
R89 VDD.n16 VDD.n12 0.0755
R90 VDD.n23 VDD.n12 0.0755
R91 VDD.n24 VDD.n23 0.0755
R92 VDD.n24 VDD.n8 0.0755
R93 VDD.n31 VDD.n8 0.0755
R94 VDD.n32 VDD.n31 0.0755
R95 VDD.n32 VDD.n4 0.0755
R96 VDD.n39 VDD.n4 0.0755
R97 VDD.n40 VDD.n39 0.0755
R98 VDD.n40 VDD.n1 0.0755
R99 VDD.n20 VDD.n19 0.0755
R100 VDD.n20 VDD.n10 0.0755
R101 VDD.n27 VDD.n10 0.0755
R102 VDD.n28 VDD.n27 0.0755
R103 VDD.n28 VDD.n6 0.0755
R104 VDD.n35 VDD.n6 0.0755
R105 VDD.n36 VDD.n35 0.0755
R106 VDD.n36 VDD.n2 0.0755
R107 VDD.n43 VDD.n2 0.0755
R108 VDD.n18 VDD.n17 0.07175
R109 VDD.n21 VDD.n13 0.07175
R110 VDD.n22 VDD.n11 0.07175
R111 VDD.n26 VDD.n25 0.07175
R112 VDD.n29 VDD.n9 0.07175
R113 VDD.n30 VDD.n7 0.07175
R114 VDD.n34 VDD.n33 0.07175
R115 VDD.n37 VDD.n5 0.07175
R116 VDD.n38 VDD.n3 0.07175
R117 VDD.n42 VDD.n41 0.07175
R118 VDD VDD.n0 0.054875
R119 VDD VDD.n44 0.017375
R120 VDD.n17 VDD.n14 0.00425
R121 VDD.n18 VDD.n13 0.00425
R122 VDD.n22 VDD.n21 0.00425
R123 VDD.n25 VDD.n11 0.00425
R124 VDD.n26 VDD.n9 0.00425
R125 VDD.n30 VDD.n29 0.00425
R126 VDD.n33 VDD.n7 0.00425
R127 VDD.n34 VDD.n5 0.00425
R128 VDD.n38 VDD.n37 0.00425
R129 VDD.n41 VDD.n3 0.00425
R130 VDD.n42 VDD.n0 0.00425
R131 VSS.t6 VSS.t4 393804
R132 VSS.n18 VSS.t0 1614.3
R133 VSS.t10 VSS.t8 527.822
R134 VSS.t8 VSS.t6 527.822
R135 VSS.t4 VSS.t2 527.822
R136 VSS.t2 VSS.t0 527.822
R137 VSS.t12 VSS.t10 464.219
R138 VSS.n18 VSS.t15 244.643
R139 VSS.t15 VSS.t13 121.513
R140 VSS.t13 VSS.t14 121.513
R141 VSS.t14 VSS.t12 121.513
R142 VSS.n37 VSS.t5 1.68691
R143 VSS.n59 VSS.t1 1.68691
R144 VSS.n85 VSS.t11 1.68691
R145 VSS.t7 VSS.n1 1.68691
R146 VSS.n109 VSS.n108 1.5755
R147 VSS.n37 VSS.n36 1.5744
R148 VSS.n109 VSS.n1 1.52994
R149 VSS.n108 VSS.n107 1.5005
R150 VSS.n3 VSS.n2 1.5005
R151 VSS.n101 VSS.n100 1.5005
R152 VSS.n99 VSS.n98 1.5005
R153 VSS.n7 VSS.n6 1.5005
R154 VSS.n91 VSS.n90 1.5005
R155 VSS.n89 VSS.n88 1.5005
R156 VSS.n13 VSS.n12 1.5005
R157 VSS.n82 VSS.n81 1.5005
R158 VSS.n80 VSS.n79 1.5005
R159 VSS.n17 VSS.n16 1.5005
R160 VSS.n74 VSS.n73 1.5005
R161 VSS.n72 VSS.n71 1.5005
R162 VSS.n22 VSS.n21 1.5005
R163 VSS.n65 VSS.n64 1.5005
R164 VSS.n63 VSS.n62 1.5005
R165 VSS.n26 VSS.n25 1.5005
R166 VSS.n54 VSS.n53 1.5005
R167 VSS.n52 VSS.n29 1.5005
R168 VSS.n51 VSS.n50 1.5005
R169 VSS.n32 VSS.n31 1.5005
R170 VSS.n43 VSS.n42 1.5005
R171 VSS.n41 VSS.n40 1.5005
R172 VSS.n39 VSS.n38 1.5005
R173 VSS.n35 VSS.n34 1.5005
R174 VSS.n45 VSS.n44 1.5005
R175 VSS.n48 VSS.n47 1.5005
R176 VSS.n49 VSS.n28 1.5005
R177 VSS.n56 VSS.n55 1.5005
R178 VSS.n30 VSS.n27 1.5005
R179 VSS.n61 VSS.n60 1.5005
R180 VSS.n24 VSS.n23 1.5005
R181 VSS.n67 VSS.n66 1.5005
R182 VSS.n70 VSS.n69 1.5005
R183 VSS.n68 VSS.n20 1.5005
R184 VSS.n76 VSS.n75 1.5005
R185 VSS.n78 VSS.n77 1.5005
R186 VSS.n15 VSS.n14 1.5005
R187 VSS.n84 VSS.n83 1.5005
R188 VSS.n87 VSS.n86 1.5005
R189 VSS.n11 VSS.n10 1.5005
R190 VSS.n93 VSS.n92 1.5005
R191 VSS.n97 VSS.n96 1.5005
R192 VSS.n95 VSS.n5 1.5005
R193 VSS.n103 VSS.n102 1.5005
R194 VSS.n106 VSS.n105 1.5005
R195 VSS.n104 VSS.n0 1.5005
R196 VSS.n46 VSS.n33 1.48306
R197 VSS.n58 VSS.n57 1.48306
R198 VSS.n94 VSS.n9 1.48306
R199 VSS.n8 VSS.n4 1.48306
R200 VSS.n41 VSS.n36 0.827786
R201 VSS.t5 VSS.n33 0.215885
R202 VSS.n33 VSS.t3 0.215885
R203 VSS.n58 VSS.t3 0.215885
R204 VSS.t1 VSS.n58 0.215885
R205 VSS.t11 VSS.n9 0.215885
R206 VSS.n9 VSS.t9 0.215885
R207 VSS.t9 VSS.n8 0.215885
R208 VSS.n8 VSS.t7 0.215885
R209 VSS.n19 VSS.n18 0.0967963
R210 VSS.n38 VSS.n34 0.0755
R211 VSS.n45 VSS.n34 0.0755
R212 VSS.n47 VSS.n28 0.0755
R213 VSS.n56 VSS.n28 0.0755
R214 VSS.n60 VSS.n27 0.0755
R215 VSS.n67 VSS.n23 0.0755
R216 VSS.n69 VSS.n67 0.0755
R217 VSS.n69 VSS.n68 0.0755
R218 VSS.n77 VSS.n76 0.0755
R219 VSS.n77 VSS.n14 0.0755
R220 VSS.n84 VSS.n14 0.0755
R221 VSS.n86 VSS.n10 0.0755
R222 VSS.n93 VSS.n10 0.0755
R223 VSS.n96 VSS.n95 0.0755
R224 VSS.n105 VSS.n103 0.0755
R225 VSS.n105 VSS.n104 0.0755
R226 VSS.n42 VSS.n41 0.0755
R227 VSS.n42 VSS.n31 0.0755
R228 VSS.n51 VSS.n31 0.0755
R229 VSS.n52 VSS.n51 0.0755
R230 VSS.n53 VSS.n52 0.0755
R231 VSS.n53 VSS.n25 0.0755
R232 VSS.n63 VSS.n25 0.0755
R233 VSS.n64 VSS.n63 0.0755
R234 VSS.n64 VSS.n21 0.0755
R235 VSS.n72 VSS.n21 0.0755
R236 VSS.n73 VSS.n72 0.0755
R237 VSS.n73 VSS.n16 0.0755
R238 VSS.n80 VSS.n16 0.0755
R239 VSS.n81 VSS.n80 0.0755
R240 VSS.n81 VSS.n12 0.0755
R241 VSS.n89 VSS.n12 0.0755
R242 VSS.n90 VSS.n89 0.0755
R243 VSS.n90 VSS.n6 0.0755
R244 VSS.n99 VSS.n6 0.0755
R245 VSS.n100 VSS.n99 0.0755
R246 VSS.n100 VSS.n2 0.0755
R247 VSS.n108 VSS.n2 0.0755
R248 VSS.n40 VSS.n39 0.07175
R249 VSS.n43 VSS.n35 0.07175
R250 VSS.n44 VSS.n32 0.07175
R251 VSS.n50 VSS.n48 0.07175
R252 VSS.n49 VSS.n29 0.07175
R253 VSS.n55 VSS.n54 0.07175
R254 VSS.n30 VSS.n26 0.07175
R255 VSS.n62 VSS.n61 0.07175
R256 VSS.n65 VSS.n24 0.07175
R257 VSS.n66 VSS.n22 0.07175
R258 VSS.n71 VSS.n70 0.07175
R259 VSS.n74 VSS.n20 0.07175
R260 VSS.n75 VSS.n17 0.07175
R261 VSS.n79 VSS.n78 0.07175
R262 VSS.n82 VSS.n15 0.07175
R263 VSS.n83 VSS.n13 0.07175
R264 VSS.n88 VSS.n87 0.07175
R265 VSS.n91 VSS.n11 0.07175
R266 VSS.n92 VSS.n7 0.07175
R267 VSS.n98 VSS.n97 0.07175
R268 VSS.n101 VSS.n5 0.07175
R269 VSS.n102 VSS.n3 0.07175
R270 VSS.n107 VSS.n106 0.07175
R271 VSS.n57 VSS.n27 0.071375
R272 VSS.n96 VSS.n94 0.067625
R273 VSS.n95 VSS.n4 0.066875
R274 VSS.n60 VSS.n59 0.0625625
R275 VSS.n47 VSS.n46 0.054875
R276 VSS VSS.n0 0.054875
R277 VSS.n86 VSS.n85 0.0505625
R278 VSS.n104 VSS.n1 0.0498125
R279 VSS.n76 VSS.n19 0.047
R280 VSS.n39 VSS.n36 0.0386786
R281 VSS.n38 VSS.n37 0.0378125
R282 VSS.n68 VSS.n19 0.029
R283 VSS.n85 VSS.n84 0.0254375
R284 VSS.n46 VSS.n45 0.021125
R285 VSS VSS.n109 0.017375
R286 VSS.n59 VSS.n23 0.0134375
R287 VSS.n103 VSS.n4 0.009125
R288 VSS.n94 VSS.n93 0.008375
R289 VSS.n57 VSS.n56 0.004625
R290 VSS.n40 VSS.n35 0.00425
R291 VSS.n44 VSS.n43 0.00425
R292 VSS.n48 VSS.n32 0.00425
R293 VSS.n50 VSS.n49 0.00425
R294 VSS.n55 VSS.n29 0.00425
R295 VSS.n54 VSS.n30 0.00425
R296 VSS.n61 VSS.n26 0.00425
R297 VSS.n62 VSS.n24 0.00425
R298 VSS.n66 VSS.n65 0.00425
R299 VSS.n70 VSS.n22 0.00425
R300 VSS.n71 VSS.n20 0.00425
R301 VSS.n75 VSS.n74 0.00425
R302 VSS.n78 VSS.n17 0.00425
R303 VSS.n79 VSS.n15 0.00425
R304 VSS.n83 VSS.n82 0.00425
R305 VSS.n87 VSS.n13 0.00425
R306 VSS.n88 VSS.n11 0.00425
R307 VSS.n92 VSS.n91 0.00425
R308 VSS.n97 VSS.n7 0.00425
R309 VSS.n98 VSS.n5 0.00425
R310 VSS.n102 VSS.n101 0.00425
R311 VSS.n106 VSS.n3 0.00425
R312 VSS.n107 VSS.n0 0.00425
C0 lo lob 2.09599f
C1 rfn lo 1.14054f
C2 rfp bbn 1.5904f
C3 rfp lob 1.13241f
C4 rfn rfp 2.58231f
C5 VDD lo 0.6759f
C6 rfp VDD 0.44704f
C7 rfp lo 1.12024f
C8 bbn bbp 0.95565f
C9 bbp lob 1.24465f
C10 rfn bbp 3.73332f
C11 VDD bbp 0.10032f
C12 bbn lob 1.95104f
C13 rfn bbn 1.44397f
C14 rfn lob 1.05507f
C15 lo bbp 2.22567f
C16 rfp bbp 2.18678f
C17 VDD bbn 0.14198f
C18 VDD lob 0.65003f
C19 rfn VDD 0.10587f
C20 lo bbn 1.23007f
C21 bbn VSS 4.90876f
C22 rfn VSS 0.130314f
C23 bbp VSS 4.12343f
C24 rfp VSS 1.03443f
C25 lo VSS 0.564984f
C26 lob VSS 0.374596f
C27 VDD VSS 33.4524f
C28 VDD.n0 VSS 0.00883147f
C29 VDD.n1 VSS 0.0379961f
C30 VDD.n2 VSS 0.0227863f
C31 VDD.n3 VSS 0.0113979f
C32 VDD.n4 VSS 0.0227863f
C33 VDD.n5 VSS 0.0113979f
C34 VDD.n6 VSS 0.0227863f
C35 VDD.n7 VSS 0.0113979f
C36 VDD.n8 VSS 0.0227863f
C37 VDD.n9 VSS 0.0113979f
C38 VDD.n10 VSS 0.0227863f
C39 VDD.n11 VSS 0.0113979f
C40 VDD.n12 VSS 0.0227863f
C41 VDD.n13 VSS 0.0113979f
C42 VDD.n14 VSS 0.399294f
C43 VDD.t1 VSS 0.0902772f
C44 VDD.t3 VSS 0.115658f
C45 VDD.t0 VSS 0.115658f
C46 VDD.t2 VSS 0.109176f
C47 VDD.n15 VSS 0.365874f
C48 VDD.n16 VSS 0.0286173f
C49 VDD.n17 VSS 0.0113979f
C50 VDD.n18 VSS 0.0113979f
C51 VDD.n19 VSS 0.0549136f
C52 VDD.n20 VSS 0.0227863f
C53 VDD.n21 VSS 0.0113979f
C54 VDD.n22 VSS 0.0113979f
C55 VDD.n23 VSS 0.0227863f
C56 VDD.n24 VSS 0.0227863f
C57 VDD.n25 VSS 0.0113979f
C58 VDD.n26 VSS 0.0113979f
C59 VDD.n27 VSS 0.0227863f
C60 VDD.n28 VSS 0.0227863f
C61 VDD.n29 VSS 0.0113979f
C62 VDD.n30 VSS 0.0113979f
C63 VDD.n31 VSS 0.0227863f
C64 VDD.n32 VSS 0.0227863f
C65 VDD.n33 VSS 0.0113979f
C66 VDD.n34 VSS 0.0113979f
C67 VDD.n35 VSS 0.0227863f
C68 VDD.n36 VSS 0.0227863f
C69 VDD.n37 VSS 0.0113979f
C70 VDD.n38 VSS 0.0113979f
C71 VDD.n39 VSS 0.0227863f
C72 VDD.n40 VSS 0.0227863f
C73 VDD.n41 VSS 0.0113979f
C74 VDD.n42 VSS 0.0113979f
C75 VDD.n43 VSS 0.0390717f
C76 VDD.n44 VSS 0.00982217f
C77 lob.t2 VSS 0.119736f
C78 lob.t3 VSS 0.119517f
C79 lob.n0 VSS 0.166888f
C80 lob.t1 VSS 0.063267f
C81 lob.t0 VSS 0.0628275f
C82 lob.n1 VSS 0.193863f
C83 lob.n2 VSS 0.0821349f
C84 lo.t2 VSS 0.142207f
C85 lo.t3 VSS 0.14192f
C86 lo.n0 VSS 0.238617f
C87 lo.n1 VSS 0.022718f
C88 lo.t1 VSS 0.0744654f
C89 lo.t0 VSS 0.0739924f
C90 lo.n2 VSS 0.218866f
C91 lo.n3 VSS 0.0220919f
C92 rfp.t1 VSS 0.646706f
C93 rfp.t2 VSS 0.636425f
C94 rfp.n0 VSS 0.150958f
C95 rfp.t0 VSS 0.304688f
C96 rfp.n1 VSS 0.0663127f
C97 rfp.t3 VSS 0.304688f
C98 rfp.n2 VSS 0.0752275f
C99 bbp.t6 VSS 1.01076f
C100 bbp.t5 VSS 1.00105f
C101 bbp.n0 VSS 0.325147f
C102 bbp.t4 VSS 1.00105f
C103 bbp.n1 VSS 0.179891f
C104 bbp.t0 VSS 0.051253f
C105 bbp.t3 VSS 0.051253f
C106 bbp.n2 VSS 0.194543f
C107 bbp.n3 VSS 0.0753274f
C108 bbp.t1 VSS 0.102502f
C109 bbp.t2 VSS 0.102502f
C110 bbp.n4 VSS 0.330131f
C111 bbp.n5 VSS 0.0634882f
C112 bbp.n6 VSS 0.115219f
C113 rfn.t3 VSS 0.0526279f
C114 rfn.t1 VSS 0.0526279f
C115 rfn.n0 VSS 0.197662f
C116 rfn.t2 VSS 0.0263136f
C117 rfn.t0 VSS 0.0263136f
C118 rfn.n1 VSS 0.0973352f
C119 rfn.n2 VSS 0.0682952f
C120 bbn.t0 VSS 0.0443999f
C121 bbn.t2 VSS 0.0443999f
C122 bbn.n0 VSS 0.190252f
C123 bbn.t1 VSS 0.0888052f
C124 bbn.t3 VSS 0.0888052f
C125 bbn.n1 VSS 0.307795f
C126 bbn.n2 VSS 0.107598f
C127 bbn.t6 VSS 0.873913f
C128 bbn.n3 VSS 0.149355f
C129 bbn.t5 VSS 0.873913f
C130 bbn.n4 VSS 0.160199f
C131 bbn.t4 VSS 0.873913f
C132 bbn.n5 VSS 0.161888f
.ends
