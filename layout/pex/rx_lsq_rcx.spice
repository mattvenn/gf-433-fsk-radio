* rx_lsq: magic R+C extraction of layout/rx_lsq.gds (layout/gen/pex.sh)
* rcfix.py: split-net C to VSS scaled by (S - K) / S on 4 nets (coupling double count removed)
* extracted 2026-11-15T23:54:31+01:00 with magic 8.3.642, mode rc, from rx_lsq.gds
.subckt rx_lsq VDD VSS aq qenb lsq
X0 VSS.t11 vq VSS.t11 VSS.t10 nfet_03v3 ad=3.6855p pd=17.28u as=0 ps=0 w=8.19u l=10u
X1 lf lsq.t3 VSS.t21 ppolyf_u_1k r_width=1u r_length=0.15912m
X2 D1x D1qb VSS.t9 VSS.t8 nfet_03v3 ad=1p pd=4u as=0.28p ps=1.56u w=1u l=0.28u
X3 a_3350_160# D1y VSS.t19 VSS.t18 nfet_03v3 ad=0.28p pd=1.56u as=0.45p ps=2.9u w=1u l=0.28u
X4 vq qenb.t2 VDD.t1 VDD.t0 pfet_03v3 ad=5p pd=11u as=4.5p ps=20.9u w=10u l=0.28u
X5 vq lg lo1 vq pfet_03v3 ad=0.225p pd=1.9u as=1.1p ps=5.4u w=0.5u l=0.28u
X6 lo2 lo1 VSS.t1 VSS.t0 nfet_03v3 ad=0.6p pd=3.2u as=0.27p ps=2.1u w=0.6u l=0.28u
X7 VSS.t17 lg lo1 VSS.t16 nfet_03v3 ad=0.1686p pd=1.74u as=0.5448p ps=5.16u w=0.22u l=0.28u
X8 lsq.t1 lo2 vq vq pfet_03v3 ad=3p pd=8u as=1.35p ps=6.9u w=3u l=0.28u
X9 lsq.t0 qenb.t0 VSS.t28 VSS.t27 nfet_03v3 ad=0.42p pd=2.84u as=0.189p ps=1.74u w=0.42u l=0.28u
X10 VDD.t3 qenb.t1 vq VDD.t2 pfet_03v3 ad=4.5p pd=20.9u as=5p ps=11u w=10u l=0.28u
X11 D1qb D1y vq vq pfet_03v3 ad=2p pd=6u as=0.9p ps=4.9u w=2u l=0.28u
X12 a_3668_1223# D1qb vq vq pfet_03v3 ad=0.56p pd=2.56u as=0.56p ps=2.56u w=2u l=0.28u
X13 vq D1qb q1 vq pfet_03v3 ad=0.675p pd=3.9u as=1.5p ps=5u w=1.5u l=0.28u
X14 VSS.t15 vq VSS.t15 VSS.t14 nfet_03v3 ad=2.2932p pd=8.75u as=0 ps=0 w=8.19u l=10u
X15 vq lsq.t8 D1y vq pfet_03v3 ad=0.56p pd=2.56u as=2p ps=6u w=2u l=0.28u
X16 VSS.t26 lsq.t4 a_4094_160# VSS.t25 nfet_03v3 ad=0.28p pd=1.56u as=0.28p ps=1.56u w=1u l=0.28u
X17 D1x lsq.t7 a_3668_1223# vq pfet_03v3 ad=2p pd=6u as=0.56p ps=2.56u w=2u l=0.28u
X18 lf VSS.t29 lg vq pfet_03v3 ad=0.2808p pd=2.76u as=0.2808p ps=2.76u w=0.22u l=2u
X19 tt lsq.t6 VSS.t23 VSS.t22 nfet_03v3 ad=0.42p pd=2.84u as=0.189p ps=1.74u w=0.42u l=0.28u
X20 a_4094_160# D1x D1y VSS.t20 nfet_03v3 ad=0.28p pd=1.56u as=1p ps=4u w=1u l=0.28u
X21 VSS.t13 vq VSS.t13 VSS.t12 nfet_03v3 ad=2.2932p pd=8.75u as=0 ps=0 w=8.19u l=10u
X22 VSS.t5 lf VSS.t5 VSS.t4 nfet_03v3 ad=7.2p pd=32.9u as=0 ps=0 w=16u l=16u
X23 tt lsq.t9 vq vq pfet_03v3 ad=1.05p pd=4.1u as=0.4725p ps=3u w=1.05u l=0.28u
X24 VSS.t7 D1qb q1 VSS.t6 nfet_03v3 ad=0.27p pd=2.1u as=0.6p ps=3.2u w=0.6u l=0.28u
X25 lsq.t2 lo2 VSS.t3 VSS.t2 nfet_03v3 ad=1.2p pd=4.4u as=0.54p ps=3.3u w=1.2u l=0.28u
X26 lo2 lo1 vq vq pfet_03v3 ad=1.5p pd=5u as=0.675p ps=3.9u w=1.5u l=0.28u
X27 D1qb lsq.t5 a_3350_160# VSS.t24 nfet_03v3 ad=1p pd=4u as=0.28p ps=1.56u w=1u l=0.28u
R0 lsq.n2 lsq.t7 49.486
R1 lsq.n1 lsq.t8 44.9774
R2 lsq.n4 lsq.t9 32.7631
R3 lsq.n8 lsq.t4 31.7904
R4 lsq.n1 lsq.t5 31.7818
R5 lsq.n4 lsq.t6 24.0687
R6 lsq.n5 lsq.t0 18.6202
R7 lsq.n3 lsq.t3 16.1395
R8 lsq.n3 lsq 10.6039
R9 lsq lsq.n5 6.45682
R10 lsq.n0 lsq.t2 6.34866
R11 lsq lsq.n0 5.42655
R12 lsq.n5 lsq.n4 5.20392
R13 lsq.n2 lsq.n1 4.89839
R14 lsq.n7 lsq.n6 4.5005
R15 lsq.n9 lsq.n8 4.5005
R16 lsq.n0 lsq.t1 2.98002
R17 lsq.n6 lsq.n3 2.45774
R18 lsq.n6 lsq 2.07287
R19 lsq.n7 lsq.n2 0.459974
R20 lsq.n9 lsq.n7 0.0455
R21 lsq lsq.n9 0.0241842
R22 qenb qenb.t1 153.762
R23 qenb.n0 qenb.t2 153.689
R24 qenb qenb.t0 33.2297
R25 qenb qenb.n1 9.61155
R26 qenb.n1 qenb.n0 4.5005
R27 qenb.n1 qenb 3.45011
R28 qenb.n0 qenb 0.0739211
R29 VDD.n11 VDD.t2 10295
R30 VDD.t2 VDD.t0 98.2353
R31 VDD.n36 VDD.n35 3.0755
R32 VDD.n32 VDD.t1 1.75993
R33 VDD.n31 VDD.t3 1.75993
R34 VDD.n36 VDD.n1 1.57925
R35 VDD.n12 VDD.n9 1.5755
R36 VDD.n27 VDD.n2 1.5755
R37 VDD.n10 VDD.n9 1.5005
R38 VDD.n18 VDD.n17 1.5005
R39 VDD.n20 VDD.n19 1.5005
R40 VDD.n6 VDD.n5 1.5005
R41 VDD.n26 VDD.n25 1.5005
R42 VDD.n28 VDD.n27 1.5005
R43 VDD.n14 VDD.n13 1.5005
R44 VDD.n16 VDD.n15 1.5005
R45 VDD.n8 VDD.n7 1.5005
R46 VDD.n22 VDD.n21 1.5005
R47 VDD.n24 VDD.n23 1.5005
R48 VDD.n4 VDD.n3 1.5005
R49 VDD.n30 VDD.n29 1.5005
R50 VDD.n34 VDD.n33 1.5005
R51 VDD.n1 VDD.n0 1.5005
R52 VDD.n12 VDD.n11 0.460111
R53 VDD.n18 VDD.n9 0.0755
R54 VDD.n19 VDD.n18 0.0755
R55 VDD.n19 VDD.n5 0.0755
R56 VDD.n26 VDD.n5 0.0755
R57 VDD.n27 VDD.n26 0.0755
R58 VDD.n15 VDD.n14 0.0755
R59 VDD.n15 VDD.n7 0.0755
R60 VDD.n22 VDD.n7 0.0755
R61 VDD.n23 VDD.n22 0.0755
R62 VDD.n23 VDD.n3 0.0755
R63 VDD.n30 VDD.n3 0.0755
R64 VDD.n35 VDD.n34 0.07175
R65 VDD.n14 VDD.n11 0.0696875
R66 VDD VDD.n0 0.054875
R67 VDD.n13 VDD.n10 0.05225
R68 VDD.n17 VDD.n16 0.05225
R69 VDD.n20 VDD.n8 0.05225
R70 VDD.n21 VDD.n6 0.05225
R71 VDD.n25 VDD.n24 0.05225
R72 VDD.n28 VDD.n4 0.05225
R73 VDD.n29 VDD.n2 0.05225
R74 VDD.n33 VDD.n32 0.0498125
R75 VDD.n31 VDD.n30 0.0464375
R76 VDD.n33 VDD.n31 0.0295625
R77 VDD.n32 VDD.n1 0.0261875
R78 VDD.n13 VDD.n12 0.02375
R79 VDD.n16 VDD.n10 0.02375
R80 VDD.n17 VDD.n8 0.02375
R81 VDD.n21 VDD.n20 0.02375
R82 VDD.n24 VDD.n6 0.02375
R83 VDD.n25 VDD.n4 0.02375
R84 VDD.n29 VDD.n28 0.02375
R85 VDD.n34 VDD.n2 0.02375
R86 VDD VDD.n36 0.017375
R87 VDD.n35 VDD.n0 0.00425
R88 VSS.t4 VSS.n80 349075
R89 VSS.t4 VSS.t22 67636.1
R90 VSS.n80 VSS.t16 9012.44
R91 VSS.t6 VSS.t27 4481.21
R92 VSS.t16 VSS.t0 1742.02
R93 VSS.n79 VSS.t24 1137.6
R94 VSS.t0 VSS.t2 1029.74
R95 VSS.t2 VSS.t8 1029.74
R96 VSS.t27 VSS.t22 948.341
R97 VSS.t18 VSS.t6 724.484
R98 VSS.n81 VSS.t10 611.944
R99 VSS.t8 VSS.t25 341.892
R100 VSS.t25 VSS.t20 341.892
R101 VSS.t24 VSS.t18 341.892
R102 VSS.n80 VSS.t21 188.155
R103 VSS.n81 VSS.t21 52.0884
R104 VSS.t10 VSS.t4 41.1039
R105 VSS.t20 VSS.n79 34.5966
R106 VSS.t21 VSS.t12 14.4575
R107 VSS.n42 VSS.t17 13.0008
R108 VSS.n41 VSS.t29 11.6669
R109 VSS.n65 VSS.t28 10.6521
R110 VSS.n61 VSS.t23 10.6521
R111 VSS.n48 VSS.t1 9.43826
R112 VSS.n58 VSS.t7 9.43826
R113 VSS.t21 VSS.t14 8.75476
R114 VSS.n57 VSS.t19 5.12789
R115 VSS.n50 VSS.t3 4.82596
R116 VSS.n62 VSS.n1 4.13124
R117 VSS.n52 VSS.n51 3.45839
R118 VSS.t5 VSS.n2 2.64712
R119 VSS.n11 VSS.t5 2.64712
R120 VSS.n120 VSS.n1 2.25925
R121 VSS.n1 VSS.n0 2.251
R122 VSS.n51 VSS.t9 1.7645
R123 VSS.n51 VSS.t26 1.7645
R124 VSS.n21 VSS.t15 1.68691
R125 VSS.n115 VSS.t11 1.68691
R126 VSS.n120 VSS.n119 1.5755
R127 VSS.n100 VSS.n10 1.5755
R128 VSS.n111 VSS.n110 1.5755
R129 VSS.n25 VSS.n20 1.5755
R130 VSS.n88 VSS.n36 1.5755
R131 VSS.n21 VSS.n20 1.54644
R132 VSS.n62 VSS.n61 1.52292
R133 VSS.n25 VSS.n24 1.5005
R134 VSS.n27 VSS.n26 1.5005
R135 VSS.n17 VSS.n16 1.5005
R136 VSS.n34 VSS.n33 1.5005
R137 VSS.n35 VSS.n14 1.5005
R138 VSS.n90 VSS.n89 1.5005
R139 VSS.n88 VSS.n87 1.5005
R140 VSS.n100 VSS.n99 1.5005
R141 VSS.n102 VSS.n101 1.5005
R142 VSS.n7 VSS.n6 1.5005
R143 VSS.n109 VSS.n108 1.5005
R144 VSS.n110 VSS.n5 1.5005
R145 VSS.n119 VSS.n118 1.5005
R146 VSS.n117 VSS.n116 1.5005
R147 VSS.n114 VSS.n3 1.5005
R148 VSS.n113 VSS.n112 1.5005
R149 VSS.n107 VSS.n4 1.5005
R150 VSS.n106 VSS.n105 1.5005
R151 VSS.n104 VSS.n103 1.5005
R152 VSS.n9 VSS.n8 1.5005
R153 VSS.n98 VSS.n97 1.5005
R154 VSS.n84 VSS.n83 1.5005
R155 VSS.n86 VSS.n85 1.5005
R156 VSS.n15 VSS.n13 1.5005
R157 VSS.n92 VSS.n91 1.5005
R158 VSS.n32 VSS.n12 1.5005
R159 VSS.n31 VSS.n30 1.5005
R160 VSS.n29 VSS.n28 1.5005
R161 VSS.n19 VSS.n18 1.5005
R162 VSS.n23 VSS.n22 1.5005
R163 VSS.n64 VSS.n63 1.5005
R164 VSS.n66 VSS.n60 1.5005
R165 VSS.n68 VSS.n67 1.5005
R166 VSS.n69 VSS.n59 1.5005
R167 VSS.n71 VSS.n70 1.5005
R168 VSS.n72 VSS.n56 1.5005
R169 VSS.n74 VSS.n73 1.5005
R170 VSS.n75 VSS.n38 1.5005
R171 VSS.n77 VSS.n76 1.5005
R172 VSS.n55 VSS.n37 1.5005
R173 VSS.n54 VSS.n53 1.5005
R174 VSS.n49 VSS.n39 1.5005
R175 VSS.n47 VSS.n46 1.5005
R176 VSS.n45 VSS.n40 1.5005
R177 VSS.n44 VSS.n43 1.5005
R178 VSS.n94 VSS.n93 1.48306
R179 VSS.n96 VSS.n95 1.48306
R180 VSS.n44 VSS.n41 0.513873
R181 VSS.n94 VSS.t15 0.215885
R182 VSS.t13 VSS.n94 0.215885
R183 VSS.n95 VSS.t13 0.215885
R184 VSS.n95 VSS.t11 0.215885
R185 VSS.n79 VSS.n78 0.122853
R186 VSS.n82 VSS.n81 0.122853
R187 VSS.n42 VSS.n41 0.0872074
R188 VSS.n43 VSS.n40 0.0755
R189 VSS.n47 VSS.n40 0.0755
R190 VSS.n77 VSS.n38 0.0755
R191 VSS.n73 VSS.n72 0.0755
R192 VSS.n72 VSS.n71 0.0755
R193 VSS.n71 VSS.n59 0.0755
R194 VSS.n67 VSS.n59 0.0755
R195 VSS.n67 VSS.n66 0.0755
R196 VSS.n22 VSS.n18 0.0755
R197 VSS.n29 VSS.n18 0.0755
R198 VSS.n30 VSS.n29 0.0755
R199 VSS.n30 VSS.n12 0.0755
R200 VSS.n92 VSS.n13 0.0755
R201 VSS.n85 VSS.n13 0.0755
R202 VSS.n85 VSS.n84 0.0755
R203 VSS.n104 VSS.n8 0.0755
R204 VSS.n105 VSS.n104 0.0755
R205 VSS.n105 VSS.n4 0.0755
R206 VSS.n113 VSS.n4 0.0755
R207 VSS.n114 VSS.n113 0.0755
R208 VSS.n101 VSS.n100 0.0755
R209 VSS.n101 VSS.n6 0.0755
R210 VSS.n109 VSS.n6 0.0755
R211 VSS.n110 VSS.n109 0.0755
R212 VSS.n26 VSS.n25 0.0755
R213 VSS.n26 VSS.n16 0.0755
R214 VSS.n34 VSS.n16 0.0755
R215 VSS.n35 VSS.n34 0.0755
R216 VSS.n89 VSS.n35 0.0755
R217 VSS.n89 VSS.n88 0.0755
R218 VSS.n117 VSS.n3 0.0755
R219 VSS.n118 VSS.n117 0.0755
R220 VSS.n45 VSS.n44 0.0755
R221 VSS.n46 VSS.n45 0.0755
R222 VSS.n46 VSS.n39 0.0755
R223 VSS.n54 VSS.n39 0.0755
R224 VSS.n55 VSS.n54 0.0755
R225 VSS.n76 VSS.n55 0.0755
R226 VSS.n76 VSS.n75 0.0755
R227 VSS.n75 VSS.n74 0.0755
R228 VSS.n74 VSS.n56 0.0755
R229 VSS.n70 VSS.n56 0.0755
R230 VSS.n70 VSS.n69 0.0755
R231 VSS.n69 VSS.n68 0.0755
R232 VSS.n68 VSS.n60 0.0755
R233 VSS.n63 VSS.n60 0.0755
R234 VSS.n49 VSS.n48 0.0741875
R235 VSS.n116 VSS.n2 0.072875
R236 VSS.n97 VSS.n96 0.068375
R237 VSS.n116 VSS.n115 0.0621875
R238 VSS.n64 VSS.n61 0.0610625
R239 VSS.n118 VSS.n0 0.0605
R240 VSS.n78 VSS.n77 0.0584375
R241 VSS.n23 VSS.n20 0.056
R242 VSS.n24 VSS.n19 0.056
R243 VSS.n28 VSS.n27 0.056
R244 VSS.n31 VSS.n17 0.056
R245 VSS.n33 VSS.n32 0.056
R246 VSS.n91 VSS.n14 0.056
R247 VSS.n90 VSS.n15 0.056
R248 VSS.n87 VSS.n86 0.056
R249 VSS.n83 VSS.n36 0.056
R250 VSS.n63 VSS 0.054875
R251 VSS.n53 VSS.n50 0.0543125
R252 VSS.n22 VSS.n21 0.0490625
R253 VSS.n66 VSS.n65 0.0486875
R254 VSS.n93 VSS.n12 0.047375
R255 VSS.n53 VSS.n52 0.042125
R256 VSS.n43 VSS.n42 0.041375
R257 VSS.n83 VSS.n10 0.041
R258 VSS.n99 VSS.n98 0.041
R259 VSS.n102 VSS.n9 0.041
R260 VSS.n103 VSS.n7 0.041
R261 VSS.n108 VSS.n106 0.041
R262 VSS.n107 VSS.n5 0.041
R263 VSS.n112 VSS.n111 0.041
R264 VSS.n58 VSS.n57 0.036875
R265 VSS.n82 VSS.n11 0.0363125
R266 VSS.n98 VSS.n10 0.035
R267 VSS.n99 VSS.n9 0.035
R268 VSS.n103 VSS.n102 0.035
R269 VSS.n106 VSS.n7 0.035
R270 VSS.n108 VSS.n107 0.035
R271 VSS.n112 VSS.n5 0.035
R272 VSS.n111 VSS.n3 0.035
R273 VSS.n52 VSS.n37 0.033875
R274 VSS.n93 VSS.n92 0.028625
R275 VSS.n65 VSS.n64 0.0273125
R276 VSS.n97 VSS.n11 0.022625
R277 VSS.n50 VSS.n49 0.0216875
R278 VSS.n73 VSS.n58 0.0205625
R279 VSS.n24 VSS.n23 0.02
R280 VSS.n27 VSS.n19 0.02
R281 VSS.n28 VSS.n17 0.02
R282 VSS.n33 VSS.n31 0.02
R283 VSS.n32 VSS.n14 0.02
R284 VSS.n91 VSS.n90 0.02
R285 VSS.n87 VSS.n15 0.02
R286 VSS.n86 VSS.n36 0.02
R287 VSS.n57 VSS.n38 0.0190625
R288 VSS.n78 VSS.n37 0.0175625
R289 VSS.n84 VSS.n82 0.0175625
R290 VSS VSS.n62 0.0140889
R291 VSS.n115 VSS.n114 0.0138125
R292 VSS VSS.n120 0.009875
R293 VSS.n96 VSS.n8 0.007625
R294 VSS VSS.n0 0.006125
R295 VSS.n119 VSS.n2 0.003125
R296 VSS.n48 VSS.n47 0.0018125
C0 D1x D1y 0.88042f
C1 a_3668_1223# D1y 0.00509f
C2 qenb tt 0.08632f
C3 lsq lo2 0.96379f
C4 qenb VDD 1.06123f
C5 D1qb lo2 0.02485f
C6 lsq vq 2.05308f
C7 D1qb vq 0.59062f
C8 lf lo2 0
C9 lg lo2 0.00588f
C10 lf vq 3.23667f
C11 lg vq 0.33992f
C12 lsq D1qb 1.76399f
C13 D1x q1 0
C14 D1y a_3350_160# 0.01134f
C15 lsq lf 0.33461f
C16 q1 D1y 0.00721f
C17 a_4094_160# vq 0.00409f
C18 D1qb lf 0.00156f
C19 lg lsq 0
C20 lg lf 0.22692f
C21 lsq a_4094_160# 0.01348f
C22 a_4094_160# D1qb 0.0061f
C23 tt vq 0.16377f
C24 VDD vq 1.55227f
C25 lo1 lo2 1.04229f
C26 lo1 vq 0.28227f
C27 lsq tt 0.83329f
C28 lsq VDD 0.48944f
C29 D1x lo2 0.08987f
C30 D1x vq 0.26831f
C31 lsq lo1 0.12133f
C32 D1y lo2 0.003f
C33 a_3668_1223# vq 0.23085f
C34 lo1 D1qb 0
C35 vq D1y 0.51666f
C36 lo1 lf 0.00642f
C37 lsq D1x 0.65684f
C38 D1qb D1x 0.70987f
C39 lg lo1 0.20859f
C40 lsq a_3668_1223# 0.02603f
C41 D1qb a_3668_1223# 0.01794f
C42 lsq D1y 1.40306f
C43 D1qb D1y 0.74379f
C44 a_3668_1223# lf 0
C45 lo1 a_4094_160# 0
C46 lf D1y 0
C47 qenb vq 2.09938f
C48 vq a_3350_160# 0.00198f
C49 q1 vq 0.21914f
C50 a_4094_160# D1x 0.00911f
C51 a_4094_160# D1y 0.07136f
C52 lsq qenb 0.29513f
C53 lsq a_3350_160# 0.01386f
C54 D1qb a_3350_160# 0.07726f
C55 lsq q1 0.04689f
C56 aq vq 0.03342f
C57 D1qb q1 0.74328f
C58 qenb lf 0.30415f
C59 q1 lf 0
C60 lo1 D1x 0
C61 aq lf 0.00402f
C62 lo1 D1y 0
C63 lg aq 1.98512f
C64 vq lo2 0.39275f
C65 D1x a_3668_1223# 0.14135f
C66 aq VSS 0.59049f
C67 lsq VSS 3.23558f
C68 qenb VSS 2.27911f
C69 VDD VSS 19.006f
C70 a_4094_160# VSS 0.14599f
C71 a_3350_160# VSS 0.14869f
C72 lg VSS 1.43835f
C73 lo1 VSS 0.65272f
C74 D1x VSS 0.56776f
C75 a_3668_1223# VSS 0.01195f
C76 tt VSS 0.30547f
C77 q1 VSS 0.35733f
C78 D1y VSS 0.5322f
C79 D1qb VSS 1.02159f
C80 lo2 VSS 0.69051f
C81 lf VSS 7.22305f
C82 vq VSS 43.551f
C83 VDD.n0 VSS 0.0133075f
C84 VDD.n1 VSS 0.0459595f
C85 VDD.n2 VSS 0.0183908f
C86 VDD.t3 VSS 0.0457845f
C87 VDD.n3 VSS 0.0343318f
C88 VDD.n4 VSS 0.0171659f
C89 VDD.n5 VSS 0.0343318f
C90 VDD.n6 VSS 0.0171659f
C91 VDD.n7 VSS 0.0343318f
C92 VDD.n8 VSS 0.0171659f
C93 VDD.n9 VSS 0.0712884f
C94 VDD.n10 VSS 0.0171659f
C95 VDD.t0 VSS 0.149034f
C96 VDD.t2 VSS 0.24097f
C97 VDD.n11 VSS 0.68248f
C98 VDD.n12 VSS 0.545074f
C99 VDD.n13 VSS 0.0171659f
C100 VDD.n14 VSS 0.0330019f
C101 VDD.n15 VSS 0.0343318f
C102 VDD.n16 VSS 0.0171659f
C103 VDD.n17 VSS 0.0171659f
C104 VDD.n18 VSS 0.0343318f
C105 VDD.n19 VSS 0.0343318f
C106 VDD.n20 VSS 0.0171659f
C107 VDD.n21 VSS 0.0171659f
C108 VDD.n22 VSS 0.0343318f
C109 VDD.n23 VSS 0.0343318f
C110 VDD.n24 VSS 0.0171659f
C111 VDD.n25 VSS 0.0171659f
C112 VDD.n26 VSS 0.0343318f
C113 VDD.n27 VSS 0.0588645f
C114 VDD.n28 VSS 0.0171659f
C115 VDD.n29 VSS 0.0171659f
C116 VDD.n30 VSS 0.0276824f
C117 VDD.n31 VSS 0.0323982f
C118 VDD.t1 VSS 0.0457845f
C119 VDD.n32 VSS 0.0323982f
C120 VDD.n33 VSS 0.0179446f
C121 VDD.n34 VSS 0.021628f
C122 VDD.n35 VSS 0.0439734f
C123 VDD.n36 VSS 0.040325f
C124 qenb.t1 VSS 0.128611f
C125 qenb.t2 VSS 0.128565f
C126 qenb.n0 VSS 0.0990428f
C127 qenb.n1 VSS 0.61673f
C128 qenb.t0 VSS 0.0223856f
C129 lsq.t1 VSS 0.181991f
C130 lsq.t2 VSS 0.0637342f
C131 lsq.n0 VSS 0.296927f
C132 lsq.t8 VSS 0.0338662f
C133 lsq.t5 VSS 0.0189805f
C134 lsq.n1 VSS 0.136363f
C135 lsq.t7 VSS 0.0414057f
C136 lsq.n2 VSS 0.150211f
C137 lsq.t3 VSS 0.0379146f
C138 lsq.n3 VSS 0.760684f
C139 lsq.t0 VSS 0.032945f
C140 lsq.t9 VSS 0.0204319f
C141 lsq.t6 VSS 0.0104192f
C142 lsq.n4 VSS 0.129121f
C143 lsq.n5 VSS 0.165487f
C144 lsq.n6 VSS 0.265066f
C145 lsq.n7 VSS 0.0289778f
C146 lsq.t4 VSS 0.018996f
C147 lsq.n8 VSS 0.0592096f
C148 lsq.n9 VSS 0.00394396f
.ends
