* rx_lsq: magic R+C extraction of layout/rx_lsq.gds (layout/gen/pex.sh)
* rcfix.py: split-net C to VSS scaled by (S - K) / S on 4 nets (coupling double count removed)
* extracted 2026-11-16T12:08:59+01:00 with magic 8.3.642, mode rc, from rx_lsq.gds
.subckt rx_lsq VDD VSS aq qenb lsq
X0 vq qenb.t4 VDD.t5 VDD.t4 pfet_03v3 ad=1.6675p pd=4.335u as=0.9338p ps=3.895u w=3.335u l=0.28u
X1 lf lsq.t3 VSS.t20 ppolyf_u_1k r_width=1u r_length=0.15912m
X2 D1x D1qb VSS.t24 VSS.t23 nfet_03v3 ad=1p pd=4u as=0.28p ps=1.56u w=1u l=0.28u
X3 a_3350_160# D1y VSS.t12 VSS.t11 nfet_03v3 ad=0.28p pd=1.56u as=0.45p ps=2.9u w=1u l=0.28u
X4 VSS.t16 vq VSS.t16 VSS.t15 nfet_03v3 ad=2.2932p pd=8.75u as=0 ps=0 w=8.19u l=10u
X5 vq lg lo1 vq pfet_03v3 ad=0.225p pd=1.9u as=1.1p ps=5.4u w=0.5u l=0.28u
X6 lo2 lo1 VSS.t8 VSS.t7 nfet_03v3 ad=0.6p pd=3.2u as=0.27p ps=2.1u w=0.6u l=0.28u
X7 VSS.t1 lg lo1 VSS.t0 nfet_03v3 ad=0.1686p pd=1.74u as=0.5448p ps=5.16u w=0.22u l=0.28u
X8 VDD.t11 qenb.t1 vq VDD.t10 pfet_03v3 ad=1.50075p pd=7.57u as=1.6675p ps=4.335u w=3.335u l=0.28u
X9 lsq.t2 lo2 vq vq pfet_03v3 ad=3p pd=8u as=1.35p ps=6.9u w=3u l=0.28u
X10 lsq.t0 qenb.t0 VSS.t26 VSS.t25 nfet_03v3 ad=0.42p pd=2.84u as=0.189p ps=1.74u w=0.42u l=0.28u
X11 D1qb D1y vq vq pfet_03v3 ad=2p pd=6u as=0.9p ps=4.9u w=2u l=0.28u
X12 a_3668_1223# D1qb vq vq pfet_03v3 ad=0.56p pd=2.56u as=0.56p ps=2.56u w=2u l=0.28u
X13 vq D1qb q1 vq pfet_03v3 ad=0.675p pd=3.9u as=1.5p ps=5u w=1.5u l=0.28u
X14 VDD.t7 qenb.t3 vq VDD.t6 pfet_03v3 ad=0.9338p pd=3.895u as=1.6675p ps=4.335u w=3.335u l=0.28u
X15 vq lsq.t8 D1y vq pfet_03v3 ad=0.56p pd=2.56u as=2p ps=6u w=2u l=0.28u
X16 VSS.t6 lsq.t4 a_4094_160# VSS.t5 nfet_03v3 ad=0.28p pd=1.56u as=0.28p ps=1.56u w=1u l=0.28u
X17 vq qenb.t2 VDD.t9 VDD.t8 pfet_03v3 ad=1.6675p pd=4.335u as=0.9338p ps=3.895u w=3.335u l=0.28u
X18 D1x lsq.t7 a_3668_1223# vq pfet_03v3 ad=2p pd=6u as=0.56p ps=2.56u w=2u l=0.28u
X19 vq qenb.t6 VDD.t1 VDD.t0 pfet_03v3 ad=1.6675p pd=4.335u as=1.50075p ps=7.57u w=3.335u l=0.28u
X20 lf VSS.t29 lg vq pfet_03v3 ad=0.2808p pd=2.76u as=0.2808p ps=2.76u w=0.22u l=2u
X21 tt lsq.t6 VSS.t3 VSS.t2 nfet_03v3 ad=0.42p pd=2.84u as=0.189p ps=1.74u w=0.42u l=0.28u
X22 a_4094_160# D1x D1y VSS.t19 nfet_03v3 ad=0.28p pd=1.56u as=1p ps=4u w=1u l=0.28u
X23 VSS.t14 vq VSS.t14 VSS.t13 nfet_03v3 ad=3.6855p pd=17.28u as=0 ps=0 w=8.19u l=10u
X24 VSS.t28 lf VSS.t28 VSS.t27 nfet_03v3 ad=7.2p pd=32.9u as=0 ps=0 w=16u l=16u
X25 tt lsq.t9 vq vq pfet_03v3 ad=1.05p pd=4.1u as=0.4725p ps=3u w=1.05u l=0.28u
X26 VSS.t22 D1qb q1 VSS.t21 nfet_03v3 ad=0.27p pd=2.1u as=0.6p ps=3.2u w=0.6u l=0.28u
X27 lsq.t1 lo2 VSS.t10 VSS.t9 nfet_03v3 ad=1.2p pd=4.4u as=0.54p ps=3.3u w=1.2u l=0.28u
X28 VDD.t3 qenb.t5 vq VDD.t2 pfet_03v3 ad=0.9338p pd=3.895u as=1.6675p ps=4.335u w=3.335u l=0.28u
X29 lo2 lo1 vq vq pfet_03v3 ad=1.5p pd=5u as=0.675p ps=3.9u w=1.5u l=0.28u
X30 VSS.t18 vq VSS.t18 VSS.t17 nfet_03v3 ad=2.2932p pd=8.75u as=0 ps=0 w=8.19u l=10u
X31 D1qb lsq.t5 a_3350_160# VSS.t4 nfet_03v3 ad=1p pd=4u as=0.28p ps=1.56u w=1u l=0.28u
R0 lsq.n2 lsq.t7 49.486
R1 lsq.n1 lsq.t8 44.9774
R2 lsq.n4 lsq.t9 32.7631
R3 lsq.n8 lsq.t4 31.7904
R4 lsq.n1 lsq.t5 31.7818
R5 lsq.n4 lsq.t6 24.0687
R6 lsq.n5 lsq.t0 18.6202
R7 lsq.n3 lsq.t3 16.1395
R8 lsq.n3 lsq 9.02537
R9 lsq lsq.n5 6.45682
R10 lsq.n0 lsq.t1 6.34866
R11 lsq lsq.n0 5.42655
R12 lsq.n5 lsq.n4 5.20392
R13 lsq.n2 lsq.n1 4.89839
R14 lsq.n7 lsq.n6 4.5005
R15 lsq.n9 lsq.n8 4.5005
R16 lsq.n0 lsq.t2 2.98002
R17 lsq.n6 lsq.n3 2.45774
R18 lsq.n6 lsq 2.07287
R19 lsq.n7 lsq.n2 0.459974
R20 lsq.n9 lsq.n7 0.0455
R21 lsq lsq.n9 0.0241842
R22 qenb.n0 qenb.t1 66.8046
R23 qenb.n4 qenb.t6 66.5014
R24 qenb.n3 qenb.t5 66.5014
R25 qenb.n2 qenb.t4 66.5014
R26 qenb.n1 qenb.t3 66.5014
R27 qenb.n0 qenb.t2 66.5014
R28 qenb qenb.t0 33.2297
R29 qenb qenb.n5 9.77261
R30 qenb.n5 qenb.n4 5.13287
R31 qenb.n5 qenb 1.7105
R32 qenb.n2 qenb.n1 0.303658
R33 qenb.n4 qenb.n3 0.303658
R34 qenb.n1 qenb.n0 0.199447
R35 qenb qenb.n2 0.165105
R36 qenb.n3 qenb 0.0348421
R37 VDD.n12 VDD.t10 5219.25
R38 VDD.t10 VDD.t8 201.101
R39 VDD.t6 VDD.t4 201.101
R40 VDD.t2 VDD.t0 201.101
R41 VDD.t8 VDD.t6 131.972
R42 VDD.t4 VDD.t2 131.972
R43 VDD.n40 VDD.n39 3.0755
R44 VDD.n36 VDD.t1 1.83721
R45 VDD.n8 VDD.t11 1.83721
R46 VDD.n40 VDD.n1 1.57925
R47 VDD.n13 VDD.n10 1.5755
R48 VDD.n32 VDD.n2 1.5755
R49 VDD.n11 VDD.n10 1.5005
R50 VDD.n20 VDD.n19 1.5005
R51 VDD.n22 VDD.n21 1.5005
R52 VDD.n7 VDD.n6 1.5005
R53 VDD.n31 VDD.n30 1.5005
R54 VDD.n33 VDD.n32 1.5005
R55 VDD.n15 VDD.n14 1.5005
R56 VDD.n18 VDD.n17 1.5005
R57 VDD.n16 VDD.n9 1.5005
R58 VDD.n24 VDD.n23 1.5005
R59 VDD.n29 VDD.n28 1.5005
R60 VDD.n26 VDD.n5 1.5005
R61 VDD.n35 VDD.n34 1.5005
R62 VDD.n38 VDD.n37 1.5005
R63 VDD.n1 VDD.n0 1.5005
R64 VDD.n4 VDD.n3 1.28099
R65 VDD.n27 VDD.n25 1.28099
R66 VDD.n3 VDD.t5 0.588206
R67 VDD.n3 VDD.t3 0.588206
R68 VDD.n25 VDD.t9 0.588206
R69 VDD.n25 VDD.t7 0.588206
R70 VDD.n13 VDD.n12 0.460111
R71 VDD.n20 VDD.n10 0.0755
R72 VDD.n21 VDD.n20 0.0755
R73 VDD.n21 VDD.n6 0.0755
R74 VDD.n31 VDD.n6 0.0755
R75 VDD.n32 VDD.n31 0.0755
R76 VDD.n17 VDD.n15 0.0755
R77 VDD.n17 VDD.n16 0.0755
R78 VDD.n28 VDD.n24 0.0755
R79 VDD.n37 VDD.n1 0.0755
R80 VDD.n16 VDD.n8 0.0749375
R81 VDD.n27 VDD.n26 0.072125
R82 VDD.n39 VDD.n38 0.07175
R83 VDD.n15 VDD.n12 0.0696875
R84 VDD.n35 VDD.n4 0.067625
R85 VDD.n37 VDD.n36 0.0636875
R86 VDD VDD.n0 0.054875
R87 VDD.n14 VDD.n11 0.05225
R88 VDD.n19 VDD.n18 0.05225
R89 VDD.n22 VDD.n9 0.05225
R90 VDD.n23 VDD.n7 0.05225
R91 VDD.n30 VDD.n29 0.05225
R92 VDD.n33 VDD.n5 0.05225
R93 VDD.n34 VDD.n2 0.05225
R94 VDD.n14 VDD.n13 0.02375
R95 VDD.n18 VDD.n11 0.02375
R96 VDD.n19 VDD.n9 0.02375
R97 VDD.n23 VDD.n22 0.02375
R98 VDD.n29 VDD.n7 0.02375
R99 VDD.n30 VDD.n5 0.02375
R100 VDD.n34 VDD.n33 0.02375
R101 VDD.n38 VDD.n2 0.02375
R102 VDD VDD.n40 0.017375
R103 VDD.n36 VDD.n35 0.0123125
R104 VDD.n26 VDD.n4 0.008375
R105 VDD.n39 VDD.n0 0.00425
R106 VDD.n28 VDD.n27 0.003875
R107 VDD.n24 VDD.n8 0.0010625
R108 VSS.n86 VSS.t20 334811
R109 VSS.n86 VSS.t2 62207.8
R110 VSS.t0 VSS.t20 9264.52
R111 VSS.t25 VSS.t21 4481.21
R112 VSS.t7 VSS.t0 1742.02
R113 VSS.t4 VSS.n85 1137.6
R114 VSS.t9 VSS.t7 1029.74
R115 VSS.t23 VSS.t9 1029.74
R116 VSS.t2 VSS.t25 948.341
R117 VSS.t15 VSS.t27 748.174
R118 VSS.t21 VSS.t11 724.484
R119 VSS.t13 VSS.n86 541.192
R120 VSS.t5 VSS.t23 341.892
R121 VSS.t19 VSS.t5 341.892
R122 VSS.t11 VSS.t4 341.892
R123 VSS.t27 VSS.t13 254.456
R124 VSS.n87 VSS.t15 126.754
R125 VSS.n87 VSS.t20 69.7858
R126 VSS.n85 VSS.t19 34.5966
R127 VSS.n48 VSS.t1 13.0008
R128 VSS.n47 VSS.t29 11.6669
R129 VSS.n71 VSS.t26 10.6521
R130 VSS.n67 VSS.t3 10.6521
R131 VSS.n54 VSS.t8 9.43826
R132 VSS.n64 VSS.t22 9.43826
R133 VSS.n63 VSS.t12 5.12789
R134 VSS.n56 VSS.t10 4.82596
R135 VSS.n68 VSS.n1 4.13124
R136 VSS.n58 VSS.n57 3.45839
R137 VSS.t28 VSS.n2 2.64712
R138 VSS.n11 VSS.t28 2.64712
R139 VSS.n116 VSS.n1 2.25925
R140 VSS.n1 VSS.n0 2.251
R141 VSS.n57 VSS.t24 1.7645
R142 VSS.n57 VSS.t6 1.7645
R143 VSS.n22 VSS.t18 1.68691
R144 VSS.n111 VSS.t14 1.68691
R145 VSS.n116 VSS.n115 1.5755
R146 VSS.n91 VSS.n9 1.5755
R147 VSS.n104 VSS.n100 1.5755
R148 VSS.n39 VSS.n12 1.5755
R149 VSS.n68 VSS.n67 1.52292
R150 VSS.n20 VSS.n19 1.5005
R151 VSS.n29 VSS.n28 1.5005
R152 VSS.n31 VSS.n30 1.5005
R153 VSS.n16 VSS.n15 1.5005
R154 VSS.n38 VSS.n37 1.5005
R155 VSS.n40 VSS.n39 1.5005
R156 VSS.n10 VSS.n9 1.5005
R157 VSS.n98 VSS.n97 1.5005
R158 VSS.n99 VSS.n7 1.5005
R159 VSS.n106 VSS.n105 1.5005
R160 VSS.n104 VSS.n103 1.5005
R161 VSS.n115 VSS.n114 1.5005
R162 VSS.n113 VSS.n112 1.5005
R163 VSS.n4 VSS.n3 1.5005
R164 VSS.n102 VSS.n101 1.5005
R165 VSS.n8 VSS.n6 1.5005
R166 VSS.n108 VSS.n107 1.5005
R167 VSS.n96 VSS.n5 1.5005
R168 VSS.n95 VSS.n94 1.5005
R169 VSS.n93 VSS.n92 1.5005
R170 VSS.n90 VSS.n89 1.5005
R171 VSS.n42 VSS.n41 1.5005
R172 VSS.n34 VSS.n14 1.5005
R173 VSS.n36 VSS.n35 1.5005
R174 VSS.n33 VSS.n32 1.5005
R175 VSS.n18 VSS.n17 1.5005
R176 VSS.n27 VSS.n26 1.5005
R177 VSS.n25 VSS.n24 1.5005
R178 VSS.n70 VSS.n69 1.5005
R179 VSS.n72 VSS.n66 1.5005
R180 VSS.n74 VSS.n73 1.5005
R181 VSS.n75 VSS.n65 1.5005
R182 VSS.n77 VSS.n76 1.5005
R183 VSS.n78 VSS.n62 1.5005
R184 VSS.n80 VSS.n79 1.5005
R185 VSS.n81 VSS.n44 1.5005
R186 VSS.n83 VSS.n82 1.5005
R187 VSS.n61 VSS.n43 1.5005
R188 VSS.n60 VSS.n59 1.5005
R189 VSS.n55 VSS.n45 1.5005
R190 VSS.n53 VSS.n52 1.5005
R191 VSS.n51 VSS.n46 1.5005
R192 VSS.n50 VSS.n49 1.5005
R193 VSS.n21 VSS.n13 1.48306
R194 VSS.n110 VSS.n109 1.48306
R195 VSS.t20 VSS.t17 0.938789
R196 VSS.n23 VSS.n22 0.858109
R197 VSS.n23 VSS.n19 0.839611
R198 VSS.n50 VSS.n47 0.513873
R199 VSS.t18 VSS.n21 0.215885
R200 VSS.n21 VSS.t16 0.215885
R201 VSS.n110 VSS.t16 0.215885
R202 VSS.t14 VSS.n110 0.215885
R203 VSS.n85 VSS.n84 0.122853
R204 VSS.n88 VSS.n87 0.122853
R205 VSS.n48 VSS.n47 0.0872074
R206 VSS.n24 VSS.n23 0.0786087
R207 VSS.n49 VSS.n46 0.0755
R208 VSS.n53 VSS.n46 0.0755
R209 VSS.n83 VSS.n44 0.0755
R210 VSS.n79 VSS.n78 0.0755
R211 VSS.n78 VSS.n77 0.0755
R212 VSS.n77 VSS.n65 0.0755
R213 VSS.n73 VSS.n65 0.0755
R214 VSS.n73 VSS.n72 0.0755
R215 VSS.n26 VSS.n25 0.0755
R216 VSS.n26 VSS.n17 0.0755
R217 VSS.n33 VSS.n17 0.0755
R218 VSS.n35 VSS.n33 0.0755
R219 VSS.n35 VSS.n34 0.0755
R220 VSS.n89 VSS.n42 0.0755
R221 VSS.n94 VSS.n93 0.0755
R222 VSS.n94 VSS.n5 0.0755
R223 VSS.n108 VSS.n6 0.0755
R224 VSS.n101 VSS.n6 0.0755
R225 VSS.n101 VSS.n4 0.0755
R226 VSS.n112 VSS.n4 0.0755
R227 VSS.n98 VSS.n9 0.0755
R228 VSS.n99 VSS.n98 0.0755
R229 VSS.n105 VSS.n99 0.0755
R230 VSS.n105 VSS.n104 0.0755
R231 VSS.n29 VSS.n19 0.0755
R232 VSS.n30 VSS.n29 0.0755
R233 VSS.n30 VSS.n15 0.0755
R234 VSS.n38 VSS.n15 0.0755
R235 VSS.n39 VSS.n38 0.0755
R236 VSS.n113 VSS.n3 0.0755
R237 VSS.n114 VSS.n113 0.0755
R238 VSS.n51 VSS.n50 0.0755
R239 VSS.n52 VSS.n51 0.0755
R240 VSS.n52 VSS.n45 0.0755
R241 VSS.n60 VSS.n45 0.0755
R242 VSS.n61 VSS.n60 0.0755
R243 VSS.n82 VSS.n61 0.0755
R244 VSS.n82 VSS.n81 0.0755
R245 VSS.n81 VSS.n80 0.0755
R246 VSS.n80 VSS.n62 0.0755
R247 VSS.n76 VSS.n62 0.0755
R248 VSS.n76 VSS.n75 0.0755
R249 VSS.n75 VSS.n74 0.0755
R250 VSS.n74 VSS.n66 0.0755
R251 VSS.n69 VSS.n66 0.0755
R252 VSS.n55 VSS.n54 0.0741875
R253 VSS.n70 VSS.n67 0.0610625
R254 VSS.n112 VSS.n111 0.0610625
R255 VSS.n114 VSS.n0 0.0605
R256 VSS.n84 VSS.n83 0.0584375
R257 VSS.n42 VSS.n13 0.056375
R258 VSS.n27 VSS.n20 0.056
R259 VSS.n28 VSS.n18 0.056
R260 VSS.n32 VSS.n31 0.056
R261 VSS.n36 VSS.n16 0.056
R262 VSS.n37 VSS.n14 0.056
R263 VSS.n41 VSS.n40 0.056
R264 VSS.n90 VSS.n12 0.056
R265 VSS.n69 VSS 0.054875
R266 VSS.n59 VSS.n56 0.0543125
R267 VSS.n72 VSS.n71 0.0486875
R268 VSS.n59 VSS.n58 0.042125
R269 VSS.n49 VSS.n48 0.041375
R270 VSS.n91 VSS.n90 0.041
R271 VSS.n92 VSS.n10 0.041
R272 VSS.n97 VSS.n95 0.041
R273 VSS.n96 VSS.n7 0.041
R274 VSS.n107 VSS.n106 0.041
R275 VSS.n103 VSS.n8 0.041
R276 VSS.n102 VSS.n100 0.041
R277 VSS.n109 VSS.n5 0.040625
R278 VSS.n64 VSS.n63 0.036875
R279 VSS.n88 VSS.n11 0.0363125
R280 VSS.n109 VSS.n108 0.035375
R281 VSS.n92 VSS.n91 0.035
R282 VSS.n95 VSS.n10 0.035
R283 VSS.n97 VSS.n96 0.035
R284 VSS.n107 VSS.n7 0.035
R285 VSS.n106 VSS.n8 0.035
R286 VSS.n103 VSS.n102 0.035
R287 VSS.n100 VSS.n3 0.035
R288 VSS.n58 VSS.n43 0.033875
R289 VSS.n71 VSS.n70 0.0273125
R290 VSS.n93 VSS.n11 0.022625
R291 VSS.n56 VSS.n55 0.0216875
R292 VSS.n79 VSS.n64 0.0205625
R293 VSS.n24 VSS.n20 0.02
R294 VSS.n28 VSS.n27 0.02
R295 VSS.n31 VSS.n18 0.02
R296 VSS.n32 VSS.n16 0.02
R297 VSS.n37 VSS.n36 0.02
R298 VSS.n40 VSS.n14 0.02
R299 VSS.n41 VSS.n12 0.02
R300 VSS.n34 VSS.n13 0.019625
R301 VSS.n63 VSS.n44 0.0190625
R302 VSS.n84 VSS.n43 0.0175625
R303 VSS.n89 VSS.n88 0.0175625
R304 VSS VSS.n68 0.0140889
R305 VSS.n111 VSS.n2 0.0123125
R306 VSS VSS.n116 0.009875
R307 VSS VSS.n0 0.006125
R308 VSS.n115 VSS.n2 0.003125
R309 VSS.n54 VSS.n53 0.0018125
R310 VSS.n25 VSS.n22 0.0018125
C0 qenb lsq 0.29513f
C1 a_3350_160# lsq 0.01386f
C2 D1x D1y 0.88042f
C3 a_4094_160# D1y 0.07136f
C4 lf D1y 0
C5 D1qb lo1 0
C6 vq tt 0.16377f
C7 D1x q1 0
C8 lf aq 0.00402f
C9 vq D1y 0.51666f
C10 lf q1 0
C11 D1x D1qb 0.70987f
C12 D1qb a_4094_160# 0.0061f
C13 D1y a_3668_1223# 0.00509f
C14 lf D1qb 0.00156f
C15 vq aq 0.03342f
C16 lo2 D1y 0.003f
C17 vq q1 0.21914f
C18 vq D1qb 0.59062f
C19 tt lsq 0.83329f
C20 lg lo1 0.20859f
C21 D1y lsq 1.40306f
C22 qenb tt 0.08632f
C23 D1qb a_3668_1223# 0.01794f
C24 a_3350_160# D1y 0.01134f
C25 lo2 D1qb 0.02485f
C26 q1 lsq 0.04689f
C27 D1x lo1 0
C28 lf lg 0.22692f
C29 a_4094_160# lo1 0
C30 D1qb lsq 1.76399f
C31 lf lo1 0.00642f
C32 a_3350_160# D1qb 0.07726f
C33 VDD vq 2.02528f
C34 lg vq 0.33992f
C35 D1x a_4094_160# 0.00911f
C36 vq lo1 0.28227f
C37 lo2 lg 0.00588f
C38 lo2 lo1 1.04229f
C39 vq D1x 0.26831f
C40 vq a_4094_160# 0.00409f
C41 VDD lsq 0.49096f
C42 lf vq 3.24477f
C43 lg lsq 0
C44 D1x a_3668_1223# 0.14135f
C45 qenb VDD 1.6011f
C46 lo1 lsq 0.12133f
C47 lf a_3668_1223# 0
C48 lo2 D1x 0.08987f
C49 q1 D1y 0.00721f
C50 lf lo2 0
C51 D1qb D1y 0.74379f
C52 vq a_3668_1223# 0.23085f
C53 D1x lsq 0.65684f
C54 a_4094_160# lsq 0.01348f
C55 lo2 vq 0.39275f
C56 lf lsq 0.33461f
C57 lf qenb 0.30376f
C58 D1qb q1 0.74328f
C59 vq lsq 2.04665f
C60 qenb vq 3.60286f
C61 a_3350_160# vq 0.00198f
C62 lsq a_3668_1223# 0.02603f
C63 lo2 lsq 0.96379f
C64 lo1 D1y 0
C65 lg aq 1.98512f
C66 aq VSS 0.59049f
C67 lsq VSS 2.89164f
C68 qenb VSS 1.67752f
C69 VDD VSS 16.5409f
C70 a_4094_160# VSS 0.14599f
C71 a_3350_160# VSS 0.14869f
C72 lg VSS 1.43835f
C73 lo1 VSS 0.65272f
C74 D1x VSS 0.56776f
C75 a_3668_1223# VSS 0.01195f
C76 tt VSS 0.30547f
C77 q1 VSS 0.35733f
C78 D1y VSS 0.5322f
C79 D1qb VSS 1.02159f
C80 lo2 VSS 0.69051f
C81 lf VSS 7.21235f
C82 vq VSS 42.4662f
C83 VDD.n0 VSS 0.0174627f
C84 VDD.n1 VSS 0.0751386f
C85 VDD.n2 VSS 0.0241428f
C86 VDD.t1 VSS 0.0140066f
C87 VDD.t5 VSS 0.00438433f
C88 VDD.t3 VSS 0.00438433f
C89 VDD.n3 VSS 0.0129707f
C90 VDD.n4 VSS 0.0323893f
C91 VDD.n5 VSS 0.022535f
C92 VDD.n6 VSS 0.0450699f
C93 VDD.n7 VSS 0.022535f
C94 VDD.t11 VSS 0.0140066f
C95 VDD.n8 VSS 0.0366742f
C96 VDD.n9 VSS 0.022535f
C97 VDD.n10 VSS 0.093571f
C98 VDD.n11 VSS 0.022535f
C99 VDD.t0 VSS 0.0416718f
C100 VDD.t2 VSS 0.0633448f
C101 VDD.t4 VSS 0.0633448f
C102 VDD.t6 VSS 0.0633448f
C103 VDD.t8 VSS 0.0633448f
C104 VDD.t10 VSS 0.152739f
C105 VDD.n12 VSS 0.849673f
C106 VDD.n13 VSS 0.715441f
C107 VDD.n14 VSS 0.022535f
C108 VDD.n15 VSS 0.0433211f
C109 VDD.n16 VSS 0.0448959f
C110 VDD.n17 VSS 0.0450699f
C111 VDD.n18 VSS 0.022535f
C112 VDD.n19 VSS 0.022535f
C113 VDD.n20 VSS 0.0450699f
C114 VDD.n21 VSS 0.0450699f
C115 VDD.n22 VSS 0.022535f
C116 VDD.n23 VSS 0.022535f
C117 VDD.n24 VSS 0.0227007f
C118 VDD.t9 VSS 0.00438433f
C119 VDD.t7 VSS 0.00438433f
C120 VDD.n25 VSS 0.0129707f
C121 VDD.n26 VSS 0.0238859f
C122 VDD.n27 VSS 0.0323893f
C123 VDD.n28 VSS 0.0235461f
C124 VDD.n29 VSS 0.022535f
C125 VDD.n30 VSS 0.022535f
C126 VDD.n31 VSS 0.0450699f
C127 VDD.n32 VSS 0.0772603f
C128 VDD.n33 VSS 0.022535f
C129 VDD.n34 VSS 0.022535f
C130 VDD.n35 VSS 0.0237201f
C131 VDD.n36 VSS 0.0366742f
C132 VDD.n37 VSS 0.0415227f
C133 VDD.n38 VSS 0.0283945f
C134 VDD.n39 VSS 0.0577173f
C135 VDD.n40 VSS 0.0529352f
C136 qenb.t1 VSS 0.0503141f
C137 qenb.t2 VSS 0.0500283f
C138 qenb.n0 VSS 0.131901f
C139 qenb.t3 VSS 0.0500283f
C140 qenb.n1 VSS 0.0688446f
C141 qenb.t4 VSS 0.0500283f
C142 qenb.n2 VSS 0.0671127f
C143 qenb.t5 VSS 0.0500283f
C144 qenb.n3 VSS 0.0605321f
C145 qenb.t6 VSS 0.0500283f
C146 qenb.n4 VSS 0.122714f
C147 qenb.n5 VSS 0.584296f
C148 qenb.t0 VSS 0.0239406f
C149 lsq.t2 VSS 0.182943f
C150 lsq.t1 VSS 0.0640675f
C151 lsq.n0 VSS 0.298486f
C152 lsq.t8 VSS 0.0340451f
C153 lsq.t5 VSS 0.01908f
C154 lsq.n1 VSS 0.137077f
C155 lsq.t7 VSS 0.0416217f
C156 lsq.n2 VSS 0.151001f
C157 lsq.t3 VSS 0.038112f
C158 lsq.n3 VSS 0.673528f
C159 lsq.t0 VSS 0.0331187f
C160 lsq.t9 VSS 0.0205378f
C161 lsq.t6 VSS 0.0104737f
C162 lsq.n4 VSS 0.129796f
C163 lsq.n5 VSS 0.166354f
C164 lsq.n6 VSS 0.266459f
C165 lsq.n7 VSS 0.0291293f
C166 lsq.t4 VSS 0.0190948f
C167 lsq.n8 VSS 0.0595207f
C168 lsq.n9 VSS 0.00396731f
.ends
