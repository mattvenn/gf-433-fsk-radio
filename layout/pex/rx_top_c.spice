* rx_top: magic R+C extraction of layout/rx_top.gds (layout/gen/pex.sh)
* extracted 2026-11-15T23:47:51+01:00 with magic 8.3.642, mode c, from rx_top.gds
.subckt rx_top VDD VSS inp inn ls aq en q_i q_q
X0 lna_x2i_tail lna_outn ri_p VSS nfet_03v3 ad=5p pd=11u as=5p ps=11u w=10u l=0.28u
X1 lna_vt lna_vcm VSS ppolyf_u_1k r_width=1u r_length=40u
X2 VDD oq_p VSS ppolyf_u_1k r_width=1u r_length=0.2m
X3 li_cx li_cb VDD VDD pfet_03v3 ad=2p pd=6u as=0.9p ps=4.9u w=2u l=0.5u
X4 VSS VDD VSS VSS nfet_03v3 ad=3.36p pd=12.56u as=1.59357n ps=4.15258m w=12u l=10u
X5 lo_bi_ta lo_bi_t VDD VDD pfet_03v3 ad=1.25p pd=4.5u as=1.25p ps=4.5u w=1.25u l=0.28u
X6 VSS bbq_o2p VSS VSS nfet_03v3 ad=24.57p pd=51.14u as=0 ps=0 w=24.57u l=10u
X7 VSS bbi_o2n VSS VSS nfet_03v3 ad=24.57p pd=51.14u as=0 ps=0 w=24.57u l=10u
X8 bbi_mRp3b bbi_mRp3b bbi_vb bbi_vb pfet_03v3 ad=0.42p pd=2.84u as=0.42p ps=2.84u w=0.42u l=1u
X9 bi_n lob_i ri_n VDD pfet_03v3 ad=8p pd=17u as=8p ps=17u w=16u l=0.28u
X10 bbq_t1 bq_p bbq_o1n VSS nfet_03v3 ad=10p pd=21u as=10p ps=21u w=20u l=1u
X11 VSS VDD VSS VSS nfet_03v3 ad=3.36p pd=12.56u as=0 ps=0 w=12u l=10u
X12 lna_outn inp lna_tail VSS nfet_03v3 ad=5p pd=11u as=5p ps=11u w=10u l=0.28u
X13 lsq lo_lq_lo2 VSS VSS nfet_03v3 ad=1.2p pd=4.4u as=0.54p ps=3.3u w=1.2u l=0.28u
X14 bbi_t1 bi_p bbi_o1n VSS nfet_03v3 ad=10p pd=21u as=10p ps=21u w=20u l=1u
X15 VSS bq_p VSS VSS nfet_03v3 ad=2.2932p pd=8.75u as=0 ps=0 w=8.19u l=5u
X16 lo_bq_ta lo_bq_t VDD VDD pfet_03v3 ad=1.25p pd=4.5u as=1.25p ps=4.5u w=1.25u l=0.28u
X17 lna_x2i_tail lna_outp ri_n VSS nfet_03v3 ad=5p pd=11u as=10p ps=22u w=10u l=0.28u
X18 VSS nb lna_tail VSS nfet_03v3 ad=2.8p pd=10.56u as=5p ps=11u w=10u l=0.5u
X19 oq_n lq_gln oq_n oq_n pfet_03v3 ad=12.285p pd=26.57u as=24.57p ps=53.14u w=12.285u l=10u
X20 bbq_vb VSS VSS ppolyf_u_1k r_width=1u r_length=99.99u
X21 rq_n lna_outp lna_x2q_tail VSS nfet_03v3 ad=5p pd=11u as=5p ps=11u w=10u l=0.28u
X22 VSS VDD VSS VSS nfet_03v3 ad=3.36p pd=12.56u as=0 ps=0 w=12u l=10u
X23 lo_bi_Py1 lo_bi_Py0 VDD VDD pfet_03v3 ad=2p pd=6u as=2p ps=6u w=2u l=0.28u
X24 bbq_o1p bq_n bbq_t1 VSS nfet_03v3 ad=10p pd=21u as=10p ps=21u w=20u l=1u
X25 li_lp li_gcp li_lp li_lp pfet_03v3 ad=12.285p pd=26.57u as=24.57p ps=53.14u w=12.285u l=10u
X26 lq_ct nb VSS VSS nfet_03v3 ad=2p pd=6u as=0.9p ps=4.9u w=2u l=0.5u
X27 lo_bq_a lo_bq_b VSS VSS nfet_03v3 ad=0.42p pd=2.84u as=0.42p ps=2.84u w=0.42u l=0.28u
X28 VSS nb VSS VSS nfet_03v3 ad=4.095p pd=9.19u as=0 ps=0 w=8.19u l=10u
X29 lo_bq_Py1 lo_bq_Py0 VDD VDD pfet_03v3 ad=2p pd=6u as=2p ps=6u w=2u l=0.28u
X30 lo_bi_Py2 lo_bi_Py1 VSS VSS nfet_03v3 ad=2p pd=6u as=2p ps=6u w=2u l=0.28u
X31 bbi_t3 bbi_g3p oi_n VSS nfet_03v3 ad=2p pd=5u as=4p ps=10u w=4u l=1u
X32 VSS nb lna_tail VSS nfet_03v3 ad=2.8p pd=10.56u as=5p ps=11u w=10u l=0.5u
X33 VSS VDD VSS VSS nfet_03v3 ad=3.36p pd=12.56u as=0 ps=0 w=12u l=10u
X34 VSS oq_n VSS VSS nfet_03v3 ad=12.285p pd=25.57u as=0 ps=0 w=24.57u l=10u
X35 bbq_vbt enb VDD VDD pfet_03v3 ad=1p pd=4u as=0.45p ps=2.9u w=1u l=0.28u
X36 rq_n lo_q bq_p VDD pfet_03v3 ad=8p pd=17u as=8p ps=17u w=16u l=0.28u
X37 VDD lo_bi_Ny1 lo_bi_Ny2 VDD pfet_03v3 ad=2.5p pd=7u as=1.25p ps=3.5u w=2.5u l=0.28u
X38 VSS nb bbq_t1 VSS nfet_03v3 ad=3.6p pd=16.9u as=4p ps=9u w=8u l=0.5u
X39 VSS nb lna_tail VSS nfet_03v3 ad=4.5p pd=20.9u as=5p ps=11u w=10u l=0.5u
X40 li_mRpLb li_mRpLb li_vb li_vb pfet_03v3 ad=0.42p pd=2.84u as=0.42p ps=2.84u w=0.42u l=1u
X41 bbi_o1n bi_p bbi_t1 VSS nfet_03v3 ad=10p pd=21u as=10p ps=21u w=20u l=1u
X42 lo_bi_Pgs lo_bi_a lo_bi_Py0 VSS nfet_03v3 ad=0.28p pd=1.56u as=1p ps=4u w=1u l=0.28u
X43 lsq lo_lq_lo2 lo_lq_vq lo_lq_vq pfet_03v3 ad=3p pd=8u as=1.35p ps=6.9u w=3u l=0.28u
X44 VDD lo_bq_Ny1 lo_bq_Ny2 VDD pfet_03v3 ad=2.5p pd=7u as=1.25p ps=3.5u w=2.5u l=0.28u
X45 lo_bi_b VDD lo_bi_tb VSS nfet_03v3 ad=1p pd=4u as=1p ps=4u w=1u l=0.28u
X46 rq_n lna_outp lna_x2q_tail VSS nfet_03v3 ad=5p pd=11u as=5p ps=11u w=10u l=0.28u
X47 lna_tail inn lna_outp VSS nfet_03v3 ad=5p pd=11u as=5p ps=11u w=10u l=0.28u
X48 bbi_o1n bi_p bbi_t1 VSS nfet_03v3 ad=20p pd=42u as=10p ps=21u w=20u l=1u
X49 bbq_t1 bq_p bbq_o1n VSS nfet_03v3 ad=10p pd=21u as=10p ps=21u w=20u l=1u
X50 VSS bbi_o2p VSS VSS nfet_03v3 ad=12.285p pd=25.57u as=0 ps=0 w=24.57u l=10u
X51 li_vbt enb VDD VDD pfet_03v3 ad=1p pd=4u as=0.45p ps=2.9u w=1u l=0.28u
X52 li_vgr nb VSS VSS nfet_03v3 ad=0.42p pd=2.84u as=0.42p ps=2.84u w=0.42u l=50u
X53 VSS lq_vb VSS VSS nfet_03v3 ad=3.4398p pd=12.845u as=0 ps=0 w=12.285u l=10u
X54 bbq_mRp3b bbq_mRp3b bbq_g3n bbq_g3n pfet_03v3 ad=0.42p pd=2.84u as=0.42p ps=2.84u w=0.42u l=1u
X55 lna_tail inp lna_outn VSS nfet_03v3 ad=5p pd=11u as=5p ps=11u w=10u l=0.28u
X56 bbq_o2p bbq_g2n bbq_t2 VSS nfet_03v3 ad=2p pd=5u as=2p ps=5u w=4u l=1u
X57 b_n2 b_n2 b_vh VDD pfet_03v3 ad=2p pd=5u as=2p ps=5u w=4u l=1u
X58 VDD bbq_o1n VSS ppolyf_u r_width=2u r_length=57.14u
X59 ri_p lna_outn lna_x2i_tail VSS nfet_03v3 ad=5p pd=11u as=5p ps=11u w=10u l=0.28u
X60 bbq_mRp3a bbq_mRp3a bbq_vb bbq_vb pfet_03v3 ad=0.42p pd=2.84u as=0.42p ps=2.84u w=0.42u l=1u
X61 lo_lq_D1qb lo_lq_D1y lo_lq_vq lo_lq_vq pfet_03v3 ad=2p pd=6u as=0.9p ps=4.9u w=2u l=0.28u
X62 lo_lq_D1qb lsq a_47706_713# VSS nfet_03v3 ad=1p pd=4u as=0.28p ps=1.56u w=1u l=0.28u
X63 VDD lo_bi_Ny0 lo_bi_Ny1 VDD pfet_03v3 ad=2p pd=6u as=2p ps=6u w=2u l=0.28u
X64 q_i li_cq VDD VDD pfet_03v3 ad=5p pd=12u as=2.25p ps=10.9u w=5u l=0.28u
X65 bbi_t1 bi_n bbi_o1p VSS nfet_03v3 ad=10p pd=21u as=10p ps=21u w=20u l=1u
X66 lq_cq lq_co VDD VDD pfet_03v3 ad=1.25p pd=4.5u as=0.5625p ps=3.4u w=1.25u l=0.28u
X67 bbq_mRp3b bbq_mRp3b bbq_vb bbq_vb pfet_03v3 ad=0.42p pd=2.84u as=0.42p ps=2.84u w=0.42u l=1u
X68 enb en VDD VDD pfet_03v3 ad=1p pd=4u as=0.45p ps=2.9u w=1u l=0.28u
X69 VDD lo_bq_Ny0 lo_bq_Ny1 VDD pfet_03v3 ad=2p pd=6u as=2p ps=6u w=2u l=0.28u
X70 lo_bi_b lo_bi_a VDD VDD pfet_03v3 ad=1.05p pd=4.1u as=1.05p ps=4.1u w=1.05u l=0.28u
X71 bbi_g2n bbi_vgr bbi_vb bbi_vb pfet_03v3 ad=0.42p pd=2.84u as=0.42p ps=2.84u w=0.42u l=12u
X72 VDD lo_bi_b lo_bi_Ny0 VDD pfet_03v3 ad=1.25p pd=4.5u as=0.625p ps=2.25u w=1.25u l=0.28u
X73 bbq_o1n bq_p bbq_t1 VSS nfet_03v3 ad=20p pd=42u as=10p ps=21u w=20u l=1u
X74 li_mRpCa li_mRpCa li_gcp li_gcp pfet_03v3 ad=0.42p pd=2.84u as=0.42p ps=2.84u w=0.42u l=1u
X75 VDD oq_n VSS ppolyf_u_1k r_width=1u r_length=0.2m
X76 bbi_t1 bi_n bbi_o1p VSS nfet_03v3 ad=10p pd=21u as=10p ps=21u w=20u l=1u
X77 bbq_o1n bq_p bbq_t1 VSS nfet_03v3 ad=10p pd=21u as=10p ps=21u w=20u l=1u
X78 VSS nb lna_tail VSS nfet_03v3 ad=2.8p pd=10.56u as=5p ps=11u w=10u l=0.5u
X79 lo_bq_Pgs lo_bq_a lo_bq_Py0 VSS nfet_03v3 ad=0.28p pd=1.56u as=1p ps=4u w=1u l=0.28u
X80 b_nr nb b_n2 VSS nfet_03v3 ad=1p pd=3u as=2p ps=6u w=2u l=0.5u
X81 li_mRpCb li_mRpCb li_gcn li_gcn pfet_03v3 ad=0.42p pd=2.84u as=0.42p ps=2.84u w=0.42u l=1u
X82 lo_bq_b VDD lo_bq_tb VSS nfet_03v3 ad=1p pd=4u as=1p ps=4u w=1u l=0.28u
X83 lo_bq_b lo_bq_a VDD VDD pfet_03v3 ad=1.05p pd=4.1u as=1.05p ps=4.1u w=1.05u l=0.28u
X84 bbq_g3n bbq_vgr bbq_vb bbq_vb pfet_03v3 ad=0.42p pd=2.84u as=0.42p ps=2.84u w=0.42u l=12u
X85 bbq_o2n bbq_g3n bbq_o2n bbq_o2n pfet_03v3 ad=12.285p pd=26.57u as=36.855p ps=79.71u w=12.285u l=10u
X86 VDD lo_bq_b lo_bq_Ny0 VDD pfet_03v3 ad=1.25p pd=4.5u as=0.625p ps=2.25u w=1.25u l=0.28u
X87 lq_lp lq_gln lq_tL VSS nfet_03v3 ad=2p pd=5u as=2p ps=5u w=4u l=0.5u
X88 a_48024_1776# lo_lq_D1qb lo_lq_vq lo_lq_vq pfet_03v3 ad=0.56p pd=2.56u as=0.56p ps=2.56u w=2u l=0.28u
X89 lq_ct lq_gcn lq_cb VSS nfet_03v3 ad=1p pd=3u as=1p ps=3u w=2u l=0.5u
X90 VSS li_vb VSS ppolyf_u_1k r_width=1u r_length=0.10002m
X91 lna_tail nb VSS VSS nfet_03v3 ad=5p pd=11u as=2.8p ps=10.56u w=10u l=0.5u
X92 li_cb li_ca VDD VDD pfet_03v3 ad=1.7p pd=5.4u as=0.765p ps=4.3u w=1.7u l=0.5u
X93 rq_p lob_q bq_n VSS nfet_03v3 ad=8p pd=18u as=4p ps=9u w=8u l=0.28u
X94 lna_outn inp lna_tail VSS nfet_03v3 ad=5p pd=11u as=5p ps=11u w=10u l=0.28u
X95 lna_x2i_tail nb VSS VSS nfet_03v3 ad=5p pd=11u as=2.8p ps=10.56u w=10u l=0.5u
X96 bbi_o1p bi_n bbi_t1 VSS nfet_03v3 ad=10p pd=21u as=10p ps=21u w=20u l=1u
X97 VSS nb lna_tail VSS nfet_03v3 ad=2.8p pd=10.56u as=5p ps=11u w=10u l=0.5u
X98 lna_outp inn lna_tail VSS nfet_03v3 ad=5p pd=11u as=5p ps=11u w=10u l=0.28u
X99 bbq_o2p bbq_g3p bbq_o2p bbq_o2p pfet_03v3 ad=6.1425p pd=13.285u as=36.855p ps=79.71u w=12.285u l=10u
X100 bbi_o2p bbi_g2n bbi_t2 VSS nfet_03v3 ad=2p pd=5u as=2p ps=5u w=4u l=1u
X101 ri_n lob_i bi_p VSS nfet_03v3 ad=4p pd=9u as=4p ps=9u w=8u l=0.28u
X102 VSS bq_p VSS VSS nfet_03v3 ad=2.2932p pd=8.75u as=0 ps=0 w=8.19u l=5u
X103 lna_vcm inn VSS ppolyf_u_1k r_width=1u r_length=20u
X104 bbq_t1 bq_n bbq_o1p VSS nfet_03v3 ad=10p pd=21u as=10p ps=21u w=20u l=1u
X105 bbi_o1p bbi_g2p bbi_o1p bbi_o1p pfet_03v3 ad=12.285p pd=26.57u as=36.855p ps=79.71u w=12.285u l=10u
X106 lna_tail nb VSS VSS nfet_03v3 ad=5p pd=11u as=2.8p ps=10.56u w=10u l=0.5u
X107 lq_lp lq_gcp lq_lp lq_lp pfet_03v3 ad=12.285p pd=26.57u as=24.57p ps=53.14u w=12.285u l=10u
X108 VSS nb lna_x2i_tail VSS nfet_03v3 ad=2.8p pd=10.56u as=5p ps=11u w=10u l=0.5u
X109 lo_bi_Py0 lo_bi_a VDD VDD pfet_03v3 ad=0.625p pd=2.25u as=1.25p ps=4.5u w=1.25u l=0.28u
X110 lq_vb lq_vbt VSS ppolyf_u_1k r_width=1u r_length=0.15m
X111 bbq_t2 nb VSS VSS nfet_03v3 ad=0.3304p pd=2.76u as=0.1774p ps=1.74u w=0.3u l=0.5u
X112 lo_bi_b VSS lo_bi_tb VDD pfet_03v3 ad=2.5p pd=7u as=2.5p ps=7u w=2.5u l=0.28u
X113 VSS bbq_o2n VSS VSS nfet_03v3 ad=12.285p pd=25.57u as=0 ps=0 w=24.57u l=10u
X114 lq_mRpCa lq_mRpCa lq_vb lq_vb pfet_03v3 ad=0.42p pd=2.84u as=0.42p ps=2.84u w=0.42u l=1u
X115 lna_tail inp lna_outn VSS nfet_03v3 ad=5p pd=11u as=5p ps=11u w=10u l=0.28u
X116 lna_outn inp lna_tail VSS nfet_03v3 ad=5p pd=11u as=5p ps=11u w=10u l=0.28u
X117 li_lp li_gln li_tL VSS nfet_03v3 ad=2p pd=5u as=2p ps=5u w=4u l=0.5u
X118 lo_bq_Py0 lo_bq_a VDD VDD pfet_03v3 ad=0.625p pd=2.25u as=1.25p ps=4.5u w=1.25u l=0.28u
X119 ri_n lna_outp lna_x2i_tail VSS nfet_03v3 ad=10p pd=22u as=5p ps=11u w=10u l=0.28u
X120 lo_bq_b VSS lo_bq_tb VDD pfet_03v3 ad=2.5p pd=7u as=2.5p ps=7u w=2.5u l=0.28u
X121 lna_x2i_tail nb VSS VSS nfet_03v3 ad=5p pd=11u as=2.8p ps=10.56u w=10u l=0.5u
X122 lq_cx lq_cx VSS VSS nfet_03v3 ad=1p pd=4u as=0.45p ps=2.9u w=1u l=0.5u
X123 bbq_o1n bbq_g2n bbq_o1n bbq_o1n pfet_03v3 ad=12.285p pd=26.57u as=36.855p ps=79.71u w=12.285u l=10u
X124 bbq_o1n bq_p bbq_t1 VSS nfet_03v3 ad=10p pd=21u as=10p ps=21u w=20u l=1u
X125 li_co li_ca VDD VDD pfet_03v3 ad=2p pd=6u as=0.9p ps=4.9u w=2u l=0.5u
X126 VSS nb lna_tail VSS nfet_03v3 ad=2.8p pd=10.56u as=5p ps=11u w=10u l=0.5u
X127 rq_n VDD VSS ppolyf_u r_width=2u r_length=9.14u
X128 bbi_g2p bbi_vgr bbi_vb bbi_vb pfet_03v3 ad=0.42p pd=2.84u as=0.42p ps=2.84u w=0.42u l=12u
X129 lna_tail inn lna_outp VSS nfet_03v3 ad=5p pd=11u as=5p ps=11u w=10u l=0.28u
X130 VSS oq_p VSS VSS nfet_03v3 ad=12.285p pd=25.57u as=0 ps=0 w=24.57u l=10u
X131 bbi_g3n bbi_vgr bbi_vb bbi_vb pfet_03v3 ad=0.42p pd=2.84u as=0.42p ps=2.84u w=0.42u l=12u
X132 VSS lo_bq_Py2 lo_q VSS nfet_03v3 ad=2.5p pd=7u as=1.25p ps=3.5u w=2.5u l=0.28u
X133 lo_bi_a lo_bi_ta VSS VSS nfet_03v3 ad=1p pd=4u as=1p ps=4u w=1u l=0.28u
X134 rq_n lna_outp lna_x2q_tail VSS nfet_03v3 ad=10p pd=22u as=5p ps=11u w=10u l=0.28u
X135 lq_gcn lq_vgr lq_vb lq_vb pfet_03v3 ad=0.42p pd=2.84u as=0.42p ps=2.84u w=0.42u l=12u
X136 bbi_t3 bbi_g3n oi_p VSS nfet_03v3 ad=2p pd=5u as=2p ps=5u w=4u l=1u
X137 lna_tail inp lna_outn VSS nfet_03v3 ad=5p pd=11u as=5p ps=11u w=10u l=0.28u
X138 VSS VDD VSS VSS nfet_03v3 ad=3.36p pd=12.56u as=0 ps=0 w=12u l=10u
X139 bbq_o1p bq_n bbq_t1 VSS nfet_03v3 ad=10p pd=21u as=10p ps=21u w=20u l=1u
X140 lo_bi_t lo_bi_x VSS VSS nfet_03v3 ad=0.42p pd=2.84u as=0.42p ps=2.84u w=0.42u l=0.28u
X141 bbq_mRp2a bbq_mRp2a bbq_g2p bbq_g2p pfet_03v3 ad=0.42p pd=2.84u as=0.42p ps=2.84u w=0.42u l=1u
X142 VSS nb lna_tail VSS nfet_03v3 ad=2.8p pd=10.56u as=5p ps=11u w=10u l=0.5u
X143 lo_lq_vq lsq lo_lq_D1y lo_lq_vq pfet_03v3 ad=0.56p pd=2.56u as=2p ps=6u w=2u l=0.28u
X144 lo_lq_D1x lo_lq_D1qb VSS VSS nfet_03v3 ad=1p pd=4u as=0.28p ps=1.56u w=1u l=0.28u
X145 li_mRpLb li_mRpLb li_gln li_gln pfet_03v3 ad=0.42p pd=2.84u as=0.42p ps=2.84u w=0.42u l=1u
X146 ri_n lo_i bi_p VDD pfet_03v3 ad=8p pd=17u as=8p ps=17u w=16u l=0.28u
X147 bbi_o2n bbi_g3n bbi_o2n bbi_o2n pfet_03v3 ad=6.1425p pd=13.285u as=36.855p ps=79.71u w=12.285u l=10u
X148 lo_bi_g0s ls lo_bi_x VSS nfet_03v3 ad=0.14p pd=1.06u as=0.5p ps=3u w=0.5u l=0.28u
X149 lo_bi_Ny0 en VDD VDD pfet_03v3 ad=0.625p pd=2.25u as=1.25p ps=4.5u w=1.25u l=0.28u
X150 VSS oi_n VSS VSS nfet_03v3 ad=12.285p pd=25.57u as=0 ps=0 w=24.57u l=10u
X151 VSS VDD VSS VSS nfet_03v3 ad=3.36p pd=12.56u as=0 ps=0 w=12u l=10u
X152 lna_tail inn lna_outp VSS nfet_03v3 ad=5p pd=11u as=5p ps=11u w=10u l=0.28u
X153 lna_vcm inp VSS ppolyf_u_1k r_width=1u r_length=20u
X154 bbq_t1 bq_n bbq_o1p VSS nfet_03v3 ad=10p pd=21u as=10p ps=21u w=20u l=1u
X155 bbq_vgr bbq_vgr bbq_vb bbq_vb pfet_03v3 ad=4p pd=10u as=4p ps=10u w=4u l=1u
X156 lo_bq_Ny0 en VDD VDD pfet_03v3 ad=0.625p pd=2.25u as=1.25p ps=4.5u w=1.25u l=0.28u
X157 lo_lq_tt lsq VSS VSS nfet_03v3 ad=0.42p pd=2.84u as=0.189p ps=1.74u w=0.42u l=0.28u
X158 bbq_vb bbq_vbt VSS ppolyf_u_1k r_width=1u r_length=0.15002m
X159 bbi_o1n bi_p bbi_t1 VSS nfet_03v3 ad=10p pd=21u as=10p ps=21u w=20u l=1u
X160 lna_tail inp lna_outn VSS nfet_03v3 ad=5p pd=11u as=5p ps=11u w=10u l=0.28u
X161 nb b_n2 b_vh VDD pfet_03v3 ad=4p pd=10u as=2p ps=5u w=4u l=1u
X162 VSS bbi_o2n VSS VSS nfet_03v3 ad=12.285p pd=25.57u as=0 ps=0 w=24.57u l=10u
X163 b_x nb VSS VSS nfet_03v3 ad=2p pd=6u as=2p ps=6u w=2u l=0.28u
X164 a_47706_713# lo_lq_D1y VSS VSS nfet_03v3 ad=0.28p pd=1.56u as=0.45p ps=2.9u w=1u l=0.28u
X165 VSS VDD VSS VSS nfet_03v3 ad=3.36p pd=12.56u as=0 ps=0 w=12u l=10u
X166 li_gcp li_vgr li_vb li_vb pfet_03v3 ad=0.42p pd=2.84u as=0.42p ps=2.84u w=0.42u l=12u
X167 bi_p lo_i ri_p VSS nfet_03v3 ad=4p pd=9u as=8p ps=18u w=8u l=0.28u
X168 lo_bq_a lo_bq_ta VSS VSS nfet_03v3 ad=1p pd=4u as=1p ps=4u w=1u l=0.28u
X169 VSS nb VSS VSS nfet_03v3 ad=4.095p pd=9.19u as=0 ps=0 w=8.19u l=10u
X170 lna_tail inn lna_outp VSS nfet_03v3 ad=5p pd=11u as=5p ps=11u w=10u l=0.28u
X171 VSS oi_p VSS VSS nfet_03v3 ad=12.285p pd=25.57u as=0 ps=0 w=24.57u l=10u
X172 b_n2 nb b_nr VSS nfet_03v3 ad=2p pd=6u as=1p ps=3u w=2u l=0.5u
X173 lq_ca lq_ca VDD VDD pfet_03v3 ad=1p pd=4u as=0.45p ps=2.9u w=1u l=0.5u
X174 lna_outp inn lna_tail VSS nfet_03v3 ad=5p pd=11u as=5p ps=11u w=10u l=0.28u
X175 VSS oq_n VSS VSS nfet_03v3 ad=24.57p pd=51.14u as=0 ps=0 w=24.57u l=10u
X176 lna_vcm VSS VSS ppolyf_u_1k r_width=1u r_length=30u
X177 lna_outp inn lna_tail VSS nfet_03v3 ad=5p pd=11u as=5p ps=11u w=10u l=0.28u
X178 VSS bbi_vb VSS VSS nfet_03v3 ad=24.57p pd=51.14u as=0 ps=0 w=24.57u l=10u
X179 bbq_o1p bq_n bbq_t1 VSS nfet_03v3 ad=10p pd=21u as=10p ps=21u w=20u l=1u
X180 VDD VSS lo_lq_vq VDD pfet_03v3 ad=4.5p pd=20.9u as=5p ps=11u w=10u l=0.28u
X181 bbi_t1 bi_n bbi_o1p VSS nfet_03v3 ad=10p pd=21u as=10p ps=21u w=20u l=1u
X182 lsq VSS VSS VSS nfet_03v3 ad=0.42p pd=2.84u as=0.189p ps=1.74u w=0.42u l=0.28u
X183 lna_x2i_tail lna_outn ri_p VSS nfet_03v3 ad=5p pd=11u as=5p ps=11u w=10u l=0.28u
X184 VSS lo_lq_vq VSS VSS nfet_03v3 ad=2.2932p pd=8.75u as=0 ps=0 w=8.19u l=10u
X185 lo_bq_g0s lsq lo_bq_x VSS nfet_03v3 ad=0.14p pd=1.06u as=0.5p ps=3u w=0.5u l=0.28u
X186 q_i li_cq VSS VSS nfet_03v3 ad=2p pd=6u as=0.9p ps=4.9u w=2u l=0.28u
X187 lna_outn inp lna_tail VSS nfet_03v3 ad=5p pd=11u as=5p ps=11u w=10u l=0.28u
X188 lo_bi_Ngs en VSS VSS nfet_03v3 ad=0.28p pd=1.56u as=1p ps=4u w=1u l=0.28u
X189 lna_x2q_tail lna_outp rq_n VSS nfet_03v3 ad=5p pd=11u as=10p ps=22u w=10u l=0.28u
X190 lna_tail inp lna_outn VSS nfet_03v3 ad=5p pd=11u as=5p ps=11u w=10u l=0.28u
X191 VSS bq_p VSS VSS nfet_03v3 ad=3.6855p pd=17.28u as=0 ps=0 w=8.19u l=5u
X192 lo_bi_a lo_bi_ta VDD VDD pfet_03v3 ad=2.5p pd=7u as=2.5p ps=7u w=2.5u l=0.28u
X193 bbi_o2n bbi_g2p bbi_t2 VSS nfet_03v3 ad=4p pd=10u as=2p ps=5u w=4u l=1u
X194 bbq_t3 bbq_g3n oq_p VSS nfet_03v3 ad=2p pd=5u as=2p ps=5u w=4u l=1u
X195 bbi_vbt enb VDD VDD pfet_03v3 ad=1p pd=4u as=0.45p ps=2.9u w=1u l=0.28u
X196 bbq_vgr nb VSS VSS nfet_03v3 ad=0.42p pd=2.84u as=0.42p ps=2.84u w=0.42u l=50u
X197 VDD oi_p VSS ppolyf_u_1k r_width=1u r_length=0.2m
X198 lo_bq_a lo_bq_ta VDD VDD pfet_03v3 ad=2.5p pd=7u as=2.5p ps=7u w=2.5u l=0.28u
X199 li_ct li_gcp li_ca VSS nfet_03v3 ad=1p pd=3u as=2p ps=6u w=2u l=0.5u
X200 VSS bbq_o2p VSS VSS nfet_03v3 ad=12.285p pd=25.57u as=0 ps=0 w=24.57u l=10u
X201 bbq_t1 nb VSS VSS nfet_03v3 ad=4p pd=9u as=3.6p ps=16.9u w=8u l=0.5u
X202 bbq_t1 bq_p bbq_o1n VSS nfet_03v3 ad=10p pd=21u as=10p ps=21u w=20u l=1u
X203 bbq_t1 bq_p bbq_o1n VSS nfet_03v3 ad=10p pd=21u as=20p ps=42u w=20u l=1u
X204 VSS lq_vb VSS ppolyf_u_1k r_width=1u r_length=0.10002m
X205 bbi_o1p bi_n bbi_t1 VSS nfet_03v3 ad=10p pd=21u as=10p ps=21u w=20u l=1u
X206 li_cb li_cb VDD VDD pfet_03v3 ad=1p pd=4u as=0.45p ps=2.9u w=1u l=0.5u
X207 bbi_mRp2a bbi_mRp2a bbi_g2p bbi_g2p pfet_03v3 ad=0.42p pd=2.84u as=0.42p ps=2.84u w=0.42u l=1u
X208 bbi_mRp2a bbi_mRp2a bbi_vb bbi_vb pfet_03v3 ad=0.42p pd=2.84u as=0.42p ps=2.84u w=0.42u l=1u
X209 bq_p lo_q rq_p VSS nfet_03v3 ad=4p pd=9u as=8p ps=18u w=8u l=0.28u
X210 VSS nb bbi_t1 VSS nfet_03v3 ad=3.6p pd=16.9u as=4p ps=9u w=8u l=0.5u
X211 bbq_o1p bq_n bbq_t1 VSS nfet_03v3 ad=10p pd=21u as=10p ps=21u w=20u l=1u
X212 VSS lo_bq_Ny1 lo_bq_Ny2 VSS nfet_03v3 ad=2p pd=6u as=2p ps=6u w=2u l=0.28u
X213 VSS li_vb VSS VSS nfet_03v3 ad=5.52825p pd=25.47u as=0 ps=0 w=12.285u l=10u
X214 lq_vgr lq_vgr lq_vb lq_vb pfet_03v3 ad=4p pd=10u as=4p ps=10u w=4u l=1u
X215 bbq_o2n bbq_g2p bbq_t2 VSS nfet_03v3 ad=4p pd=10u as=2p ps=5u w=4u l=1u
X216 VDD bbi_o1n VSS ppolyf_u r_width=2u r_length=57.14u
X217 lo_bi_a lo_bi_b VDD VDD pfet_03v3 ad=1.05p pd=4.1u as=1.05p ps=4.1u w=1.05u l=0.28u
X218 VDD bbq_o2p VSS ppolyf_u_1k r_width=1u r_length=0.2m
X219 lo_bq_Ngs en VSS VSS nfet_03v3 ad=0.28p pd=1.56u as=1p ps=4u w=1u l=0.28u
X220 bbq_o1n bq_p bbq_t1 VSS nfet_03v3 ad=10p pd=21u as=10p ps=21u w=20u l=1u
X221 rq_p lo_q bq_n VDD pfet_03v3 ad=16p pd=34u as=8p ps=17u w=16u l=0.28u
X222 lo_q lo_bq_Py2 VSS VSS nfet_03v3 ad=1.25p pd=3.5u as=2.5p ps=7u w=2.5u l=0.28u
X223 VSS en lo_bi_g0s VSS nfet_03v3 ad=0.5p pd=3u as=0.14p ps=1.06u w=0.5u l=0.28u
X224 lq_cq lq_co VSS VSS nfet_03v3 ad=0.5p pd=3u as=0.225p ps=1.9u w=0.5u l=0.28u
X225 lna_tail inp lna_outn VSS nfet_03v3 ad=5p pd=11u as=5p ps=11u w=10u l=0.28u
X226 lo_bq_a lo_bq_b VDD VDD pfet_03v3 ad=1.05p pd=4.1u as=1.05p ps=4.1u w=1.05u l=0.28u
X227 VSS li_vb VSS VSS nfet_03v3 ad=3.4398p pd=12.845u as=0 ps=0 w=12.285u l=10u
X228 bbi_t1 bi_p bbi_o1n VSS nfet_03v3 ad=10p pd=21u as=10p ps=21u w=20u l=1u
X229 bbq_o2p bbq_g3p bbq_o2p bbq_o2p pfet_03v3 ad=12.285p pd=26.57u as=0 ps=0 w=12.285u l=10u
X230 bbi_t2 nb VSS VSS nfet_03v3 ad=0.3304p pd=2.76u as=0.1774p ps=1.74u w=0.3u l=0.5u
X231 lna_outp inn lna_tail VSS nfet_03v3 ad=5p pd=11u as=5p ps=11u w=10u l=0.28u
X232 lq_co lq_cx VSS VSS nfet_03v3 ad=1p pd=4u as=0.45p ps=2.9u w=1u l=0.5u
X233 VSS bbi_o2p VSS VSS nfet_03v3 ad=24.57p pd=51.14u as=0 ps=0 w=24.57u l=10u
X234 bbq_o1p bbq_g2p bbq_o1p bbq_o1p pfet_03v3 ad=6.1425p pd=13.285u as=36.855p ps=79.71u w=12.285u l=10u
X235 lo_bq_Py2 lo_bq_Py1 VSS VSS nfet_03v3 ad=2p pd=6u as=2p ps=6u w=2u l=0.28u
X236 li_mRpCb li_mRpCb li_vb li_vb pfet_03v3 ad=0.42p pd=2.84u as=0.42p ps=2.84u w=0.42u l=1u
X237 li_ca li_gcp li_ct VSS nfet_03v3 ad=2p pd=6u as=1p ps=3u w=2u l=0.5u
X238 bbq_o1n bbq_g2n bbq_o1n bbq_o1n pfet_03v3 ad=6.1425p pd=13.285u as=0 ps=0 w=12.285u l=10u
X239 oi_n li_gln oi_n oi_n pfet_03v3 ad=12.285p pd=26.57u as=24.57p ps=53.14u w=12.285u l=10u
X240 bbi_t1 bi_p bbi_o1n VSS nfet_03v3 ad=10p pd=21u as=10p ps=21u w=20u l=1u
X241 bbq_t1 bq_p bbq_o1n VSS nfet_03v3 ad=10p pd=21u as=10p ps=21u w=20u l=1u
X242 lo_lq_D1x lsq a_48024_1776# lo_lq_vq pfet_03v3 ad=2p pd=6u as=0.56p ps=2.56u w=2u l=0.28u
X243 lna_tail inn lna_outp VSS nfet_03v3 ad=5p pd=11u as=5p ps=11u w=10u l=0.28u
X244 b_x VSS b_vh VDD pfet_03v3 ad=0.42p pd=2.84u as=0.42p ps=2.84u w=0.42u l=10u
X245 VSS bbq_o2n VSS VSS nfet_03v3 ad=12.285p pd=25.57u as=0 ps=0 w=24.57u l=10u
X246 lna_x2i_tail lna_outp ri_n VSS nfet_03v3 ad=5p pd=11u as=5p ps=11u w=10u l=0.28u
X247 lq_tL lq_glp lq_ln VSS nfet_03v3 ad=2p pd=5u as=4p ps=10u w=4u l=0.5u
X248 VSS lsq a_48450_713# VSS nfet_03v3 ad=0.28p pd=1.56u as=0.28p ps=1.56u w=1u l=0.28u
X249 lq_cb lq_gcn lq_ct VSS nfet_03v3 ad=1p pd=3u as=1p ps=3u w=2u l=0.5u
X250 VSS nb lna_tail VSS nfet_03v3 ad=2.8p pd=10.56u as=5p ps=11u w=10u l=0.5u
X251 lo_i lo_bi_Py2 VDD VDD pfet_03v3 ad=4.165p pd=10.33u as=2.0825p ps=5.165u w=4.165u l=0.28u
X252 lq_mRpLb lq_mRpLb lq_gln lq_gln pfet_03v3 ad=0.42p pd=2.84u as=0.42p ps=2.84u w=0.42u l=1u
X253 bi_p lob_i ri_p VDD pfet_03v3 ad=8p pd=17u as=16p ps=34u w=16u l=0.28u
X254 VSS lo_bi_Ny1 lo_bi_Ny2 VSS nfet_03v3 ad=2p pd=6u as=2p ps=6u w=2u l=0.28u
X255 rq_p lna_outn lna_x2q_tail VSS nfet_03v3 ad=5p pd=11u as=5p ps=11u w=10u l=0.28u
X256 bbi_mRp3a bbi_mRp3a bbi_vb bbi_vb pfet_03v3 ad=0.42p pd=2.84u as=0.42p ps=2.84u w=0.42u l=1u
X257 bbi_o1n bi_p bbi_t1 VSS nfet_03v3 ad=10p pd=21u as=10p ps=21u w=20u l=1u
X258 VSS lo_bi_Py2 lo_i VSS nfet_03v3 ad=2.5p pd=7u as=1.25p ps=3.5u w=2.5u l=0.28u
X259 lo_q lo_bq_Py2 VDD VDD pfet_03v3 ad=4.165p pd=10.33u as=2.0825p ps=5.165u w=4.165u l=0.28u
X260 VSS oq_p VSS VSS nfet_03v3 ad=12.285p pd=25.57u as=0 ps=0 w=24.57u l=10u
X261 VSS en lo_bq_g0s VSS nfet_03v3 ad=0.5p pd=3u as=0.14p ps=1.06u w=0.5u l=0.28u
X262 lna_tail nb VSS VSS nfet_03v3 ad=5p pd=11u as=2.8p ps=10.56u w=10u l=0.5u
X263 VSS nb lna_tail VSS nfet_03v3 ad=2.8p pd=10.56u as=5p ps=11u w=10u l=0.5u
X264 lna_x2q_tail lna_outp rq_n VSS nfet_03v3 ad=5p pd=11u as=5p ps=11u w=10u l=0.28u
X265 lna_outp inn lna_tail VSS nfet_03v3 ad=5p pd=11u as=5p ps=11u w=10u l=0.28u
X266 lna_x2i_tail nb VSS VSS nfet_03v3 ad=5p pd=11u as=4.5p ps=20.9u w=10u l=0.5u
X267 bbq_o1n bq_p bbq_t1 VSS nfet_03v3 ad=10p pd=21u as=10p ps=21u w=20u l=1u
X268 lq_mRpLb lq_mRpLb lq_vb lq_vb pfet_03v3 ad=0.42p pd=2.84u as=0.42p ps=2.84u w=0.42u l=1u
X269 lna_tail nb VSS VSS nfet_03v3 ad=5p pd=11u as=2.8p ps=10.56u w=10u l=0.5u
X270 lo_bi_Ny0 lo_bi_b lo_bi_Ngs VSS nfet_03v3 ad=1p pd=4u as=0.28p ps=1.56u w=1u l=0.28u
X271 bbi_t1 bi_p bbi_o1n VSS nfet_03v3 ad=10p pd=21u as=10p ps=21u w=20u l=1u
X272 lna_x2q_tail nb VSS VSS nfet_03v3 ad=5p pd=11u as=10p ps=22u w=10u l=0.5u
X273 bbq_mRp2a bbq_mRp2a bbq_vb bbq_vb pfet_03v3 ad=0.42p pd=2.84u as=0.42p ps=2.84u w=0.42u l=1u
X274 VSS bi_p VSS VSS nfet_03v3 ad=3.6855p pd=17.28u as=0 ps=0 w=8.19u l=5u
X275 li_tL li_glp li_ln VSS nfet_03v3 ad=2p pd=5u as=4p ps=10u w=4u l=0.5u
X276 bbi_o2n bbi_g3n bbi_o2n bbi_o2n pfet_03v3 ad=12.285p pd=26.57u as=0 ps=0 w=12.285u l=10u
X277 lna_tail nb VSS VSS nfet_03v3 ad=5p pd=11u as=2.8p ps=10.56u w=10u l=0.5u
X278 lo_bi_Py1 lo_bi_Py0 VSS VSS nfet_03v3 ad=0.8p pd=3.6u as=0.8p ps=3.6u w=0.8u l=0.28u
X279 VDD bbq_o1p VSS ppolyf_u r_width=2u r_length=57.14u
X280 VSS oi_n VSS VSS nfet_03v3 ad=12.285p pd=25.57u as=0 ps=0 w=24.57u l=10u
X281 lq_ca lq_cb VDD VDD pfet_03v3 ad=1.7p pd=5.4u as=0.765p ps=4.3u w=1.7u l=0.5u
X282 rq_p lna_outn lna_x2q_tail VSS nfet_03v3 ad=5p pd=11u as=5p ps=11u w=10u l=0.28u
X283 VSS nb lna_x2i_tail VSS nfet_03v3 ad=2.8p pd=10.56u as=5p ps=11u w=10u l=0.5u
X284 lna_outn inp lna_tail VSS nfet_03v3 ad=5p pd=11u as=5p ps=11u w=10u l=0.28u
X285 lq_vbt enb VDD VDD pfet_03v3 ad=1p pd=4u as=0.45p ps=2.9u w=1u l=0.28u
X286 lna_tail nb VSS VSS nfet_03v3 ad=5p pd=11u as=2.8p ps=10.56u w=10u l=0.5u
X287 lna_tail inp lna_outn VSS nfet_03v3 ad=5p pd=11u as=5p ps=11u w=10u l=0.28u
X288 q_q lq_cq VDD VDD pfet_03v3 ad=5p pd=12u as=2.25p ps=10.9u w=5u l=0.28u
X289 bbi_o2p bbi_g3p bbi_o2p bbi_o2p pfet_03v3 ad=6.1425p pd=13.285u as=36.855p ps=79.71u w=12.285u l=10u
X290 VSS bbi_o2n VSS VSS nfet_03v3 ad=12.285p pd=25.57u as=0 ps=0 w=24.57u l=10u
X291 VSS lna_vcm VSS VSS nfet_03v3 ad=4.915p pd=10.83u as=0 ps=0 w=9.83u l=10u
X292 lna_x2q_tail lna_outp rq_n VSS nfet_03v3 ad=5p pd=11u as=5p ps=11u w=10u l=0.28u
X293 ri_p lna_outn lna_x2i_tail VSS nfet_03v3 ad=5p pd=11u as=5p ps=11u w=10u l=0.28u
X294 VDD bbq_o2n VSS ppolyf_u_1k r_width=1u r_length=0.2m
X295 bbq_t1 bq_n bbq_o1p VSS nfet_03v3 ad=10p pd=21u as=10p ps=21u w=20u l=1u
X296 bbq_t1 bq_n bbq_o1p VSS nfet_03v3 ad=10p pd=21u as=10p ps=21u w=20u l=1u
X297 VSS oi_n VSS VSS nfet_03v3 ad=24.57p pd=51.14u as=0 ps=0 w=24.57u l=10u
X298 lo_bi_b lo_bi_a VSS VSS nfet_03v3 ad=0.42p pd=2.84u as=0.42p ps=2.84u w=0.42u l=0.28u
X299 VSS nb VSS VSS nfet_03v3 ad=8.19p pd=18.38u as=0 ps=0 w=8.19u l=10u
X300 lq_mRpCb lq_mRpCb lq_gcn lq_gcn pfet_03v3 ad=0.42p pd=2.84u as=0.42p ps=2.84u w=0.42u l=1u
X301 bbi_o1n bi_p bbi_t1 VSS nfet_03v3 ad=10p pd=21u as=10p ps=21u w=20u l=1u
X302 lob_q lo_bq_Ny2 VSS VSS nfet_03v3 ad=1.25p pd=3.5u as=2.5p ps=7u w=2.5u l=0.28u
X303 VSS bi_p VSS VSS nfet_03v3 ad=2.2932p pd=8.75u as=0 ps=0 w=8.19u l=5u
X304 li_cq li_co VDD VDD pfet_03v3 ad=1.25p pd=4.5u as=0.5625p ps=3.4u w=1.25u l=0.28u
X305 lna_tail inn lna_outp VSS nfet_03v3 ad=5p pd=11u as=5p ps=11u w=10u l=0.28u
X306 lna_outp inn lna_tail VSS nfet_03v3 ad=5p pd=11u as=5p ps=11u w=10u l=0.28u
X307 li_gln li_vgr li_vb li_vb pfet_03v3 ad=0.42p pd=2.84u as=0.42p ps=2.84u w=0.42u l=12u
X308 VSS nb lna_x2q_tail VSS nfet_03v3 ad=5p pd=11u as=5p ps=11u w=10u l=0.5u
X309 ri_n lna_outp lna_x2i_tail VSS nfet_03v3 ad=5p pd=11u as=5p ps=11u w=10u l=0.28u
X310 VSS nb lna_tail VSS nfet_03v3 ad=2.8p pd=10.56u as=5p ps=11u w=10u l=0.5u
X311 lo_bq_Ny0 lo_bq_b lo_bq_Ngs VSS nfet_03v3 ad=1p pd=4u as=0.28p ps=1.56u w=1u l=0.28u
X312 lo_lq_vq lo_lq_D1qb lo_lq_q1 lo_lq_vq pfet_03v3 ad=0.675p pd=3.9u as=1.5p ps=5u w=1.5u l=0.28u
X313 bbi_o1n bbi_g2n bbi_o1n bbi_o1n pfet_03v3 ad=6.1425p pd=13.285u as=36.855p ps=79.71u w=12.285u l=10u
X314 rq_p VDD VSS ppolyf_u r_width=2u r_length=9.14u
X315 lo_bq_Py1 lo_bq_Py0 VSS VSS nfet_03v3 ad=0.8p pd=3.6u as=0.8p ps=3.6u w=0.8u l=0.28u
X316 lo_bq_t lo_bq_x VSS VSS nfet_03v3 ad=0.42p pd=2.84u as=0.42p ps=2.84u w=0.42u l=0.28u
X317 bbi_t2 bbi_g2p bbi_o2n VSS nfet_03v3 ad=2p pd=5u as=4p ps=10u w=4u l=1u
X318 lna_outn inp lna_tail VSS nfet_03v3 ad=5p pd=11u as=5p ps=11u w=10u l=0.28u
X319 lq_tL nb VSS VSS nfet_03v3 ad=2p pd=6u as=0.9p ps=4.9u w=2u l=0.5u
X320 bbq_mRp3a bbq_mRp3a bbq_g3p bbq_g3p pfet_03v3 ad=0.42p pd=2.84u as=0.42p ps=2.84u w=0.42u l=1u
X321 VSS lo_bi_Ny0 lo_bi_Ny1 VSS nfet_03v3 ad=0.8p pd=3.6u as=0.8p ps=3.6u w=0.8u l=0.28u
X322 bbq_o1p bq_n bbq_t1 VSS nfet_03v3 ad=10p pd=21u as=10p ps=21u w=20u l=1u
X323 lo_bi_Py2 lo_bi_Py1 VDD VDD pfet_03v3 ad=1.25p pd=3.5u as=2.5p ps=7u w=2.5u l=0.28u
X324 bbi_t1 bi_n bbi_o1p VSS nfet_03v3 ad=10p pd=21u as=10p ps=21u w=20u l=1u
X325 VSS bi_p VSS VSS nfet_03v3 ad=2.2932p pd=8.75u as=0 ps=0 w=8.19u l=5u
X326 lob_i lo_bi_Ny2 VSS VSS nfet_03v3 ad=1.25p pd=3.5u as=2.5p ps=7u w=2.5u l=0.28u
X327 lo_lq_vq VSS VDD VDD pfet_03v3 ad=5p pd=11u as=4.5p ps=20.9u w=10u l=0.28u
X328 b_nr nb b_n2 VSS nfet_03v3 ad=1p pd=3u as=2p ps=6u w=2u l=0.5u
X329 lo_bq_Py2 lo_bq_Py1 VDD VDD pfet_03v3 ad=1.25p pd=3.5u as=2.5p ps=7u w=2.5u l=0.28u
X330 VDD lna_outp VSS ppolyf_u r_width=4u r_length=9.14u
X331 VSS bbq_o2p VSS VSS nfet_03v3 ad=12.285p pd=25.57u as=0 ps=0 w=24.57u l=10u
X332 bbq_g3p bbq_vgr bbq_vb bbq_vb pfet_03v3 ad=0.42p pd=2.84u as=0.42p ps=2.84u w=0.42u l=12u
X333 VSS nb lna_x2q_tail VSS nfet_03v3 ad=5p pd=11u as=5p ps=11u w=10u l=0.5u
X334 bbi_t1 bi_n bbi_o1p VSS nfet_03v3 ad=10p pd=21u as=10p ps=21u w=20u l=1u
X335 lna_tail inn lna_outp VSS nfet_03v3 ad=5p pd=11u as=5p ps=11u w=10u l=0.28u
X336 VSS lna_vcm VSS VSS nfet_03v3 ad=9.83p pd=21.66u as=0 ps=0 w=9.83u l=10u
X337 lna_x2q_tail nb VSS VSS nfet_03v3 ad=5p pd=11u as=5p ps=11u w=10u l=0.5u
X338 lna_outn inp lna_tail VSS nfet_03v3 ad=5p pd=11u as=5p ps=11u w=10u l=0.28u
X339 bbq_t2 bbq_g2p bbq_o2n VSS nfet_03v3 ad=2p pd=5u as=4p ps=10u w=4u l=1u
X340 b_vh b_n2 nb VDD pfet_03v3 ad=2p pd=5u as=4p ps=10u w=4u l=1u
X341 VSS bq_n VSS VSS nfet_03v3 ad=2.2932p pd=8.75u as=0 ps=0 w=8.19u l=5u
X342 bbq_g2n bbq_vgr bbq_vb bbq_vb pfet_03v3 ad=0.42p pd=2.84u as=0.42p ps=2.84u w=0.42u l=12u
X343 bq_p lob_q rq_p VDD pfet_03v3 ad=8p pd=17u as=16p ps=34u w=16u l=0.28u
X344 nb enb VSS VSS nfet_03v3 ad=0.42p pd=2.84u as=0.189p ps=1.74u w=0.42u l=0.28u
X345 oi_p bbi_g3n bbi_t3 VSS nfet_03v3 ad=2p pd=5u as=2p ps=5u w=4u l=1u
X346 lna_outp inn lna_tail VSS nfet_03v3 ad=5p pd=11u as=5p ps=11u w=10u l=0.28u
X347 lo_lq_lo2 lo_lq_lo1 lo_lq_vq lo_lq_vq pfet_03v3 ad=1.5p pd=5u as=0.675p ps=3.9u w=1.5u l=0.28u
X348 li_cx li_cx VSS VSS nfet_03v3 ad=1p pd=4u as=0.45p ps=2.9u w=1u l=0.5u
X349 bq_n lo_q rq_n VSS nfet_03v3 ad=4p pd=9u as=4p ps=9u w=8u l=0.28u
X350 bbq_t1 bq_p bbq_o1n VSS nfet_03v3 ad=10p pd=21u as=10p ps=21u w=20u l=1u
X351 lo_lq_lf lsq VSS ppolyf_u_1k r_width=1u r_length=0.15912m
X352 li_glp li_vgr li_vb li_vb pfet_03v3 ad=0.42p pd=2.84u as=0.42p ps=2.84u w=0.42u l=12u
X353 bbi_o1p bi_n bbi_t1 VSS nfet_03v3 ad=10p pd=21u as=10p ps=21u w=20u l=1u
X354 li_gcn li_vgr li_vb li_vb pfet_03v3 ad=0.42p pd=2.84u as=0.42p ps=2.84u w=0.42u l=12u
X355 lo_bi_tb lo_bi_t VDD VDD pfet_03v3 ad=3.75p pd=9.5u as=3.75p ps=9.5u w=3.75u l=0.28u
X356 lq_ln lq_glp lq_tL VSS nfet_03v3 ad=4p pd=10u as=2p ps=5u w=4u l=0.5u
X357 lo_bi_ta lo_bi_t VSS VSS nfet_03v3 ad=0.5p pd=3u as=0.5p ps=3u w=0.5u l=0.28u
X358 VSS lo_bq_Ny0 lo_bq_Ny1 VSS nfet_03v3 ad=0.8p pd=3.6u as=0.8p ps=3.6u w=0.8u l=0.28u
X359 oq_p lq_glp oq_p oq_p pfet_03v3 ad=12.285p pd=26.57u as=24.57p ps=53.14u w=12.285u l=10u
X360 lna_outn inp lna_tail VSS nfet_03v3 ad=5p pd=11u as=5p ps=11u w=10u l=0.28u
X361 VSS oq_n VSS VSS nfet_03v3 ad=12.285p pd=25.57u as=0 ps=0 w=24.57u l=10u
X362 a_48450_713# lo_lq_D1x lo_lq_D1y VSS nfet_03v3 ad=0.28p pd=1.56u as=1p ps=4u w=1u l=0.28u
X363 bbi_o1p bi_n bbi_t1 VSS nfet_03v3 ad=10p pd=21u as=10p ps=21u w=20u l=1u
X364 rq_p lna_outn lna_x2q_tail VSS nfet_03v3 ad=5p pd=11u as=5p ps=11u w=10u l=0.28u
X365 lo_bq_tb lo_bq_t VDD VDD pfet_03v3 ad=3.75p pd=9.5u as=3.75p ps=9.5u w=3.75u l=0.28u
X366 VDD lo_bi_Py2 lo_i VDD pfet_03v3 ad=2.0825p pd=5.165u as=2.0825p ps=5.165u w=4.165u l=0.28u
X367 bbi_t1 bi_n bbi_o1p VSS nfet_03v3 ad=10p pd=21u as=10p ps=21u w=20u l=1u
X368 lna_x2q_tail nb VSS VSS nfet_03v3 ad=5p pd=11u as=5p ps=11u w=10u l=0.5u
X369 VSS oi_p VSS VSS nfet_03v3 ad=12.285p pd=25.57u as=0 ps=0 w=24.57u l=10u
X370 bbq_o1p bbq_g2p bbq_o1p bbq_o1p pfet_03v3 ad=12.285p pd=26.57u as=0 ps=0 w=12.285u l=10u
X371 VDD lo_bq_Py2 lo_q VDD pfet_03v3 ad=2.0825p pd=5.165u as=2.0825p ps=5.165u w=4.165u l=0.28u
X372 lna_tail inn lna_outp VSS nfet_03v3 ad=5p pd=11u as=5p ps=11u w=10u l=0.28u
X373 lq_gcp lq_vgr lq_vb lq_vb pfet_03v3 ad=0.42p pd=2.84u as=0.42p ps=2.84u w=0.42u l=12u
X374 lq_cx lq_cb VDD VDD pfet_03v3 ad=2p pd=6u as=0.9p ps=4.9u w=2u l=0.5u
X375 lo_lq_lo2 lo_lq_lo1 VSS VSS nfet_03v3 ad=0.6p pd=3.2u as=0.27p ps=2.1u w=0.6u l=0.28u
X376 VSS bbi_o2p VSS VSS nfet_03v3 ad=12.285p pd=25.57u as=0 ps=0 w=24.57u l=10u
X377 bbq_o1n bq_p bbq_t1 VSS nfet_03v3 ad=10p pd=21u as=10p ps=21u w=20u l=1u
X378 VDD lq_ln VSS ppolyf_u r_width=1u r_length=28.56u
X379 VSS bbq_o2n VSS VSS nfet_03v3 ad=24.57p pd=51.14u as=0 ps=0 w=24.57u l=10u
X380 bbq_mRp2b bbq_mRp2b bbq_g2n bbq_g2n pfet_03v3 ad=0.42p pd=2.84u as=0.42p ps=2.84u w=0.42u l=1u
X381 li_ln li_glp li_tL VSS nfet_03v3 ad=4p pd=10u as=2p ps=5u w=4u l=0.5u
X382 lo_lq_lf VSS lo_lq_lg lo_lq_vq pfet_03v3 ad=0.2808p pd=2.76u as=0.2808p ps=2.76u w=0.22u l=2u
X383 lq_gln lq_vgr lq_vb lq_vb pfet_03v3 ad=0.42p pd=2.84u as=0.42p ps=2.84u w=0.42u l=12u
X384 lo_i lo_bi_Py2 VSS VSS nfet_03v3 ad=1.25p pd=3.5u as=2.5p ps=7u w=2.5u l=0.28u
X385 lo_bi_x ls VDD VDD pfet_03v3 ad=0.3p pd=1.6u as=0.6p ps=3.2u w=0.6u l=0.28u
X386 VSS bbq_vb VSS VSS nfet_03v3 ad=24.57p pd=51.14u as=0 ps=0 w=24.57u l=10u
X387 bbq_g2p bbq_vgr bbq_vb bbq_vb pfet_03v3 ad=0.42p pd=2.84u as=0.42p ps=2.84u w=0.42u l=12u
X388 VSS lna_vcm VSS VSS nfet_03v3 ad=4.4235p pd=20.56u as=0 ps=0 w=9.83u l=10u
X389 li_tL nb VSS VSS nfet_03v3 ad=2p pd=6u as=0.9p ps=4.9u w=2u l=0.5u
X390 lo_bq_tb lo_bq_t VSS VSS nfet_03v3 ad=1.5p pd=5u as=1.5p ps=5u w=1.5u l=0.28u
X391 lq_mRpCa lq_mRpCa lq_gcp lq_gcp pfet_03v3 ad=0.42p pd=2.84u as=0.42p ps=2.84u w=0.42u l=1u
X392 bbi_o1p bi_n bbi_t1 VSS nfet_03v3 ad=10p pd=21u as=10p ps=21u w=20u l=1u
X393 lna_x2q_tail nb VSS VSS nfet_03v3 ad=5p pd=11u as=5p ps=11u w=10u l=0.5u
X394 lo_bq_ta lo_bq_t VSS VSS nfet_03v3 ad=0.5p pd=3u as=0.5p ps=3u w=0.5u l=0.28u
X395 VSS oq_p VSS VSS nfet_03v3 ad=24.57p pd=51.14u as=0 ps=0 w=24.57u l=10u
X396 li_ca li_ca VDD VDD pfet_03v3 ad=1p pd=4u as=0.45p ps=2.9u w=1u l=0.5u
X397 lo_bq_x lsq VDD VDD pfet_03v3 ad=0.3p pd=1.6u as=0.6p ps=3.2u w=0.6u l=0.28u
X398 VDD lo_bi_Py1 lo_bi_Py2 VDD pfet_03v3 ad=2.5p pd=7u as=1.25p ps=3.5u w=2.5u l=0.28u
X399 q_q lq_cq VSS VSS nfet_03v3 ad=2p pd=6u as=0.9p ps=4.9u w=2u l=0.28u
X400 lna_tail inp lna_outn VSS nfet_03v3 ad=5p pd=11u as=5p ps=11u w=10u l=0.28u
X401 VSS nb lna_x2q_tail VSS nfet_03v3 ad=10p pd=22u as=5p ps=11u w=10u l=0.5u
X402 li_ct li_gcn li_cb VSS nfet_03v3 ad=1p pd=3u as=1p ps=3u w=2u l=0.5u
X403 lna_outp inn lna_tail VSS nfet_03v3 ad=5p pd=11u as=5p ps=11u w=10u l=0.28u
X404 VDD lo_bq_Py1 lo_bq_Py2 VDD pfet_03v3 ad=2.5p pd=7u as=1.25p ps=3.5u w=2.5u l=0.28u
X405 bbq_t1 bq_n bbq_o1p VSS nfet_03v3 ad=10p pd=21u as=10p ps=21u w=20u l=1u
X406 bbi_mRp2b bbi_mRp2b bbi_vb bbi_vb pfet_03v3 ad=0.42p pd=2.84u as=0.42p ps=2.84u w=0.42u l=1u
X407 oq_p bbq_g3n bbq_t3 VSS nfet_03v3 ad=2p pd=5u as=2p ps=5u w=4u l=1u
X408 VSS bq_n VSS VSS nfet_03v3 ad=2.2932p pd=8.75u as=0 ps=0 w=8.19u l=5u
X409 VDD bbi_o2p VSS ppolyf_u_1k r_width=1u r_length=0.2m
X410 VSS lo_lq_D1qb lo_lq_q1 VSS nfet_03v3 ad=0.27p pd=2.1u as=0.6p ps=3.2u w=0.6u l=0.28u
X411 lna_tail inn lna_outp VSS nfet_03v3 ad=5p pd=11u as=5p ps=11u w=10u l=0.28u
X412 nb nb VSS VSS nfet_03v3 ad=2p pd=6u as=0.9p ps=4.9u w=2u l=0.5u
X413 VSS lo_bi_Ny2 lob_i VSS nfet_03v3 ad=2.5p pd=7u as=1.25p ps=3.5u w=2.5u l=0.28u
X414 bbq_o1n bq_p bbq_t1 VSS nfet_03v3 ad=10p pd=21u as=10p ps=21u w=20u l=1u
X415 lna_outn inp lna_tail VSS nfet_03v3 ad=5p pd=11u as=5p ps=11u w=10u l=0.28u
X416 bbi_t1 bi_p bbi_o1n VSS nfet_03v3 ad=10p pd=21u as=10p ps=21u w=20u l=1u
X417 lna_x2i_tail lna_outp ri_n VSS nfet_03v3 ad=5p pd=11u as=5p ps=11u w=10u l=0.28u
X418 lq_vgr nb VSS VSS nfet_03v3 ad=0.42p pd=2.84u as=0.42p ps=2.84u w=0.42u l=50u
X419 bbi_o2p bbi_g3p bbi_o2p bbi_o2p pfet_03v3 ad=12.285p pd=26.57u as=0 ps=0 w=12.285u l=10u
X420 VSS bbi_o2n VSS VSS nfet_03v3 ad=12.285p pd=25.57u as=0 ps=0 w=24.57u l=10u
X421 bbi_t1 bi_p bbi_o1n VSS nfet_03v3 ad=10p pd=21u as=20p ps=42u w=20u l=1u
X422 VSS nb lna_x2q_tail VSS nfet_03v3 ad=5p pd=11u as=5p ps=11u w=10u l=0.5u
X423 VSS bq_n VSS VSS nfet_03v3 ad=3.6855p pd=17.28u as=0 ps=0 w=8.19u l=5u
X424 bi_n lo_i ri_n VSS nfet_03v3 ad=4p pd=9u as=4p ps=9u w=8u l=0.28u
X425 bbq_o1p bq_n bbq_t1 VSS nfet_03v3 ad=10p pd=21u as=10p ps=21u w=20u l=1u
X426 b_vh b_n2 b_n2 VDD pfet_03v3 ad=2p pd=5u as=2p ps=5u w=4u l=1u
X427 VDD lo_bi_Ny2 lob_i VDD pfet_03v3 ad=2.0825p pd=5.165u as=4.165p ps=10.33u w=4.165u l=0.28u
X428 bbq_t2 bbq_g2n bbq_o2p VSS nfet_03v3 ad=2p pd=5u as=2p ps=5u w=4u l=1u
X429 li_mRpLa li_mRpLa li_glp li_glp pfet_03v3 ad=0.42p pd=2.84u as=0.42p ps=2.84u w=0.42u l=1u
X430 lna_tail nb VSS VSS nfet_03v3 ad=5p pd=11u as=2.8p ps=10.56u w=10u l=0.5u
X431 VSS lo_lq_lf VSS VSS nfet_03v3 ad=7.2p pd=32.9u as=0 ps=0 w=16u l=16u
X432 li_vgr li_vgr li_vb li_vb pfet_03v3 ad=4p pd=10u as=4p ps=10u w=4u l=1u
X433 li_mRpLa li_mRpLa li_vb li_vb pfet_03v3 ad=0.42p pd=2.84u as=0.42p ps=2.84u w=0.42u l=1u
X434 VSS nb lna_tail VSS nfet_03v3 ad=2.8p pd=10.56u as=5p ps=11u w=10u l=0.5u
X435 VSS lo_bq_Ny2 lob_q VSS nfet_03v3 ad=2.5p pd=7u as=1.25p ps=3.5u w=2.5u l=0.28u
X436 VDD en lo_bi_Py0 VDD pfet_03v3 ad=1.25p pd=4.5u as=0.625p ps=2.25u w=1.25u l=0.28u
X437 bbq_t3 bbq_g3p oq_n VSS nfet_03v3 ad=2p pd=5u as=4p ps=10u w=4u l=1u
X438 oi_n bbi_g3p bbi_t3 VSS nfet_03v3 ad=4p pd=10u as=2p ps=5u w=4u l=1u
X439 bbi_t1 nb VSS VSS nfet_03v3 ad=4p pd=9u as=3.6p ps=16.9u w=8u l=0.5u
X440 VDD lo_bq_Ny2 lob_q VDD pfet_03v3 ad=2.0825p pd=5.165u as=4.165p ps=10.33u w=4.165u l=0.28u
X441 lo_bi_a lo_bi_b VSS VSS nfet_03v3 ad=0.42p pd=2.84u as=0.42p ps=2.84u w=0.42u l=0.28u
X442 bbq_t1 bq_n bbq_o1p VSS nfet_03v3 ad=10p pd=21u as=10p ps=21u w=20u l=1u
X443 lna_x2i_tail nb VSS VSS nfet_03v3 ad=5p pd=11u as=2.8p ps=10.56u w=10u l=0.5u
X444 bbi_mRp3a bbi_mRp3a bbi_g3p bbi_g3p pfet_03v3 ad=0.42p pd=2.84u as=0.42p ps=2.84u w=0.42u l=1u
X445 VDD en lo_bq_Py0 VDD pfet_03v3 ad=1.25p pd=4.5u as=0.625p ps=2.25u w=1.25u l=0.28u
X446 VDD lo_bi_Ny2 lob_i VDD pfet_03v3 ad=4.165p pd=10.33u as=2.0825p ps=5.165u w=4.165u l=0.28u
X447 bbi_o1n bi_p bbi_t1 VSS nfet_03v3 ad=10p pd=21u as=10p ps=21u w=20u l=1u
X448 VSS nb lna_tail VSS nfet_03v3 ad=2.8p pd=10.56u as=5p ps=11u w=10u l=0.5u
X449 bbi_mRp3b bbi_mRp3b bbi_g3n bbi_g3n pfet_03v3 ad=0.42p pd=2.84u as=0.42p ps=2.84u w=0.42u l=1u
X450 bbi_o1n bbi_g2n bbi_o1n bbi_o1n pfet_03v3 ad=12.285p pd=26.57u as=0 ps=0 w=12.285u l=10u
X451 VDD li_ln VSS ppolyf_u r_width=1u r_length=28.56u
X452 ri_p lob_i bi_n VSS nfet_03v3 ad=8p pd=18u as=4p ps=9u w=8u l=0.28u
X453 bbq_t3 nb VSS VSS nfet_03v3 ad=0.8p pd=3.6u as=0.36p ps=2.5u w=0.8u l=0.5u
X454 lna_tail nb VSS VSS nfet_03v3 ad=5p pd=11u as=2.8p ps=10.56u w=10u l=0.5u
X455 VSS lna_vcm VSS VSS nfet_03v3 ad=2.7524p pd=10.39u as=0 ps=0 w=9.83u l=10u
X456 VSS lo_lq_vq VSS VSS nfet_03v3 ad=3.6855p pd=17.28u as=0 ps=0 w=8.19u l=10u
X457 VDD lo_bq_Ny2 lob_q VDD pfet_03v3 ad=4.165p pd=10.33u as=2.0825p ps=5.165u w=4.165u l=0.28u
X458 li_cq li_co VSS VSS nfet_03v3 ad=0.5p pd=3u as=0.225p ps=1.9u w=0.5u l=0.28u
X459 VDD bbi_o1p VSS ppolyf_u r_width=2u r_length=57.14u
X460 lq_mRpCb lq_mRpCb lq_vb lq_vb pfet_03v3 ad=0.42p pd=2.84u as=0.42p ps=2.84u w=0.42u l=1u
X461 bbi_o1n bi_p bbi_t1 VSS nfet_03v3 ad=10p pd=21u as=10p ps=21u w=20u l=1u
X462 bbq_t1 bq_p bbq_o1n VSS nfet_03v3 ad=10p pd=21u as=10p ps=21u w=20u l=1u
X463 VSS lo_lq_lg lo_lq_lo1 VSS nfet_03v3 ad=0.1686p pd=1.74u as=0.5448p ps=5.16u w=0.22u l=0.28u
X464 lna_tail inp lna_outn VSS nfet_03v3 ad=5p pd=11u as=5p ps=11u w=10u l=0.28u
X465 VSS nb lna_x2i_tail VSS nfet_03v3 ad=2.8p pd=10.56u as=5p ps=11u w=10u l=0.5u
X466 lq_cb lq_ca VDD VDD pfet_03v3 ad=1.7p pd=5.4u as=0.765p ps=4.3u w=1.7u l=0.5u
X467 li_co li_cx VSS VSS nfet_03v3 ad=1p pd=4u as=0.45p ps=2.9u w=1u l=0.5u
X468 bbi_vb bbi_vbt VSS ppolyf_u_1k r_width=1u r_length=0.15002m
X469 lna_vt enb VDD VDD pfet_03v3 ad=2p pd=6u as=2p ps=6u w=2u l=0.28u
X470 VSS lna_vcm VSS VSS nfet_03v3 ad=2.7524p pd=10.39u as=0 ps=0 w=9.83u l=10u
X471 VSS lo_lq_vq VSS VSS nfet_03v3 ad=2.2932p pd=8.75u as=0 ps=0 w=8.19u l=10u
X472 VDD lna_outn VSS ppolyf_u r_width=4u r_length=9.14u
X473 VSS bbq_o2p VSS VSS nfet_03v3 ad=12.285p pd=25.57u as=0 ps=0 w=24.57u l=10u
X474 VSS bi_n VSS VSS nfet_03v3 ad=2.2932p pd=8.75u as=0 ps=0 w=8.19u l=5u
X475 li_ln li_gcn li_ln li_ln pfet_03v3 ad=12.285p pd=26.57u as=24.57p ps=53.14u w=12.285u l=10u
X476 VSS VDD VSS VSS nfet_03v3 ad=5.4p pd=24.9u as=0 ps=0 w=12u l=10u
X477 lna_tail inn lna_outp VSS nfet_03v3 ad=5p pd=11u as=5p ps=11u w=10u l=0.28u
X478 li_vb li_vbt VSS ppolyf_u_1k r_width=1u r_length=0.15m
X479 bbi_t1 bi_n bbi_o1p VSS nfet_03v3 ad=10p pd=21u as=10p ps=21u w=20u l=1u
X480 VDD en lo_bi_x VDD pfet_03v3 ad=0.6p pd=3.2u as=0.3p ps=1.6u w=0.6u l=0.28u
X481 bbi_t2 bbi_g2n bbi_o2p VSS nfet_03v3 ad=2p pd=5u as=2p ps=5u w=4u l=1u
X482 lna_tail inp lna_outn VSS nfet_03v3 ad=5p pd=11u as=5p ps=11u w=10u l=0.28u
X483 lna_tail inp lna_outn VSS nfet_03v3 ad=5p pd=11u as=10p ps=22u w=10u l=0.28u
X484 lo_bi_tb lo_bi_t VSS VSS nfet_03v3 ad=1.5p pd=5u as=1.5p ps=5u w=1.5u l=0.28u
X485 lna_x2q_tail lna_outn rq_p VSS nfet_03v3 ad=5p pd=11u as=5p ps=11u w=10u l=0.28u
X486 lo_bq_b lo_bq_a VSS VSS nfet_03v3 ad=0.42p pd=2.84u as=0.42p ps=2.84u w=0.42u l=0.28u
X487 lq_ct lq_gcp lq_ca VSS nfet_03v3 ad=1p pd=3u as=2p ps=6u w=2u l=0.5u
X488 bbq_mRp2b bbq_mRp2b bbq_vb bbq_vb pfet_03v3 ad=0.42p pd=2.84u as=0.42p ps=2.84u w=0.42u l=1u
X489 VDD en lo_bq_x VDD pfet_03v3 ad=0.6p pd=3.2u as=0.3p ps=1.6u w=0.6u l=0.28u
X490 ri_n lna_outp lna_x2i_tail VSS nfet_03v3 ad=5p pd=11u as=5p ps=11u w=10u l=0.28u
X491 ri_p lna_outn lna_x2i_tail VSS nfet_03v3 ad=5p pd=11u as=5p ps=11u w=10u l=0.28u
X492 VDD bbi_o2n VSS ppolyf_u_1k r_width=1u r_length=0.2m
X493 VSS nb lna_x2i_tail VSS nfet_03v3 ad=4.5p pd=20.9u as=5p ps=11u w=10u l=0.5u
X494 VSS VDD VSS VSS nfet_03v3 ad=3.36p pd=12.56u as=0 ps=0 w=12u l=10u
X495 li_mRpCa li_mRpCa li_vb li_vb pfet_03v3 ad=0.42p pd=2.84u as=0.42p ps=2.84u w=0.42u l=1u
X496 lq_co lq_ca VDD VDD pfet_03v3 ad=2p pd=6u as=0.9p ps=4.9u w=2u l=0.5u
X497 bbi_o1n bi_p bbi_t1 VSS nfet_03v3 ad=10p pd=21u as=10p ps=21u w=20u l=1u
X498 enb en VSS VSS nfet_03v3 ad=0.42p pd=2.84u as=0.189p ps=1.74u w=0.42u l=0.28u
X499 lo_i lo_bi_Py2 VDD VDD pfet_03v3 ad=2.0825p pd=5.165u as=4.165p ps=10.33u w=4.165u l=0.28u
X500 VSS oq_n VSS VSS nfet_03v3 ad=12.285p pd=25.57u as=0 ps=0 w=24.57u l=10u
X501 lo_lq_vq lo_lq_lg lo_lq_lo1 lo_lq_vq pfet_03v3 ad=0.225p pd=1.9u as=1.1p ps=5.4u w=0.5u l=0.28u
X502 bbq_t1 bq_p bbq_o1n VSS nfet_03v3 ad=10p pd=21u as=10p ps=21u w=20u l=1u
X503 lna_x2q_tail lna_outn rq_p VSS nfet_03v3 ad=5p pd=11u as=5p ps=11u w=10u l=0.28u
X504 rq_n lob_q bq_p VSS nfet_03v3 ad=4p pd=9u as=4p ps=9u w=8u l=0.28u
X505 lo_q lo_bq_Py2 VDD VDD pfet_03v3 ad=2.0825p pd=5.165u as=4.165p ps=10.33u w=4.165u l=0.28u
X506 VSS oi_p VSS VSS nfet_03v3 ad=12.285p pd=25.57u as=0 ps=0 w=24.57u l=10u
X507 bbi_mRp2b bbi_mRp2b bbi_g2n bbi_g2n pfet_03v3 ad=0.42p pd=2.84u as=0.42p ps=2.84u w=0.42u l=1u
X508 lo_bi_t lo_bi_x VDD VDD pfet_03v3 ad=1.05p pd=4.1u as=1.05p ps=4.1u w=1.05u l=0.28u
X509 li_ca li_cb VDD VDD pfet_03v3 ad=1.7p pd=5.4u as=0.765p ps=4.3u w=1.7u l=0.5u
X510 lo_lq_tt lsq lo_lq_vq lo_lq_vq pfet_03v3 ad=1.05p pd=4.1u as=0.4725p ps=3u w=1.05u l=0.28u
X511 ri_p VDD VSS ppolyf_u r_width=2u r_length=9.14u
X512 lna_outn inp lna_tail VSS nfet_03v3 ad=10p pd=22u as=5p ps=11u w=10u l=0.28u
X513 b_x enb VSS VSS nfet_03v3 ad=0.42p pd=2.84u as=0.189p ps=1.74u w=0.42u l=0.28u
X514 lna_tail inn lna_outp VSS nfet_03v3 ad=5p pd=11u as=5p ps=11u w=10u l=0.28u
X515 b_n2 nb b_nr VSS nfet_03v3 ad=2p pd=6u as=1p ps=3u w=2u l=0.5u
X516 VSS bbi_o2p VSS VSS nfet_03v3 ad=12.285p pd=25.57u as=0 ps=0 w=24.57u l=10u
X517 lna_tail nb VSS VSS nfet_03v3 ad=5p pd=11u as=2.8p ps=10.56u w=10u l=0.5u
X518 lo_bq_t lo_bq_x VDD VDD pfet_03v3 ad=1.05p pd=4.1u as=1.05p ps=4.1u w=1.05u l=0.28u
X519 bbi_t1 bi_n bbi_o1p VSS nfet_03v3 ad=10p pd=21u as=10p ps=21u w=20u l=1u
X520 lq_mRpLa lq_mRpLa lq_glp lq_glp pfet_03v3 ad=0.42p pd=2.84u as=0.42p ps=2.84u w=0.42u l=1u
X521 lq_mRpLa lq_mRpLa lq_vb lq_vb pfet_03v3 ad=0.42p pd=2.84u as=0.42p ps=2.84u w=0.42u l=1u
X522 nb b_x b_n2 VSS nfet_03v3 ad=1p pd=4u as=1p ps=4u w=1u l=0.28u
X523 lq_tL lq_gln lq_lp VSS nfet_03v3 ad=2p pd=5u as=2p ps=5u w=4u l=0.5u
X524 lna_outp inn lna_tail VSS nfet_03v3 ad=5p pd=11u as=5p ps=11u w=10u l=0.28u
X525 b_vh enb VDD VDD pfet_03v3 ad=4p pd=10u as=1.8p ps=8.9u w=4u l=0.28u
X526 lq_ca lq_gcp lq_ct VSS nfet_03v3 ad=2p pd=6u as=1p ps=3u w=2u l=0.5u
X527 bbi_vgr bbi_vgr bbi_vb bbi_vb pfet_03v3 ad=4p pd=10u as=4p ps=10u w=4u l=1u
X528 VSS oi_p VSS VSS nfet_03v3 ad=24.57p pd=51.14u as=0 ps=0 w=24.57u l=10u
X529 VSS en lo_bi_Pgs VSS nfet_03v3 ad=1p pd=4u as=0.28p ps=1.56u w=1u l=0.28u
X530 lob_i lo_bi_Ny2 VDD VDD pfet_03v3 ad=2.0825p pd=5.165u as=2.0825p ps=5.165u w=4.165u l=0.28u
X531 oi_p li_glp oi_p oi_p pfet_03v3 ad=12.285p pd=26.57u as=24.57p ps=53.14u w=12.285u l=10u
X532 bbi_g3p bbi_vgr bbi_vb bbi_vb pfet_03v3 ad=0.42p pd=2.84u as=0.42p ps=2.84u w=0.42u l=12u
X533 bbq_o1n bq_p bbq_t1 VSS nfet_03v3 ad=10p pd=21u as=10p ps=21u w=20u l=1u
X534 lna_outp inn lna_tail VSS nfet_03v3 ad=5p pd=11u as=5p ps=11u w=10u l=0.28u
X535 lq_glp lq_vgr lq_vb lq_vb pfet_03v3 ad=0.42p pd=2.84u as=0.42p ps=2.84u w=0.42u l=12u
X536 lna_tail nb VSS VSS nfet_03v3 ad=5p pd=11u as=4.5p ps=20.9u w=10u l=0.5u
X537 bq_n lob_q rq_n VDD pfet_03v3 ad=8p pd=17u as=8p ps=17u w=16u l=0.28u
X538 lna_outn inp lna_tail VSS nfet_03v3 ad=5p pd=11u as=5p ps=11u w=10u l=0.28u
X539 lob_q lo_bq_Ny2 VDD VDD pfet_03v3 ad=2.0825p pd=5.165u as=2.0825p ps=5.165u w=4.165u l=0.28u
X540 lna_tail inp lna_outn VSS nfet_03v3 ad=5p pd=11u as=5p ps=11u w=10u l=0.28u
X541 VSS oi_n VSS VSS nfet_03v3 ad=12.285p pd=25.57u as=0 ps=0 w=24.57u l=10u
X542 lna_tail nb VSS VSS nfet_03v3 ad=5p pd=11u as=2.8p ps=10.56u w=10u l=0.5u
X543 VDD oi_n VSS ppolyf_u_1k r_width=1u r_length=0.2m
X544 bbi_o1p bi_n bbi_t1 VSS nfet_03v3 ad=10p pd=21u as=10p ps=21u w=20u l=1u
X545 li_ct nb VSS VSS nfet_03v3 ad=2p pd=6u as=0.9p ps=4.9u w=2u l=0.5u
X546 ri_p lo_i bi_n VDD pfet_03v3 ad=16p pd=34u as=8p ps=17u w=16u l=0.28u
X547 li_tL li_gln li_lp VSS nfet_03v3 ad=2p pd=5u as=2p ps=5u w=4u l=0.5u
X548 lo_bi_Ny2 lo_bi_Ny1 VDD VDD pfet_03v3 ad=1.25p pd=3.5u as=2.5p ps=7u w=2.5u l=0.28u
X549 bbq_o2n bbq_g3n bbq_o2n bbq_o2n pfet_03v3 ad=6.1425p pd=13.285u as=0 ps=0 w=12.285u l=10u
X550 lna_tail inn lna_outp VSS nfet_03v3 ad=5p pd=11u as=5p ps=11u w=10u l=0.28u
X551 lna_x2q_tail lna_outn rq_p VSS nfet_03v3 ad=5p pd=11u as=5p ps=11u w=10u l=0.28u
X552 bbi_o1p bi_n bbi_t1 VSS nfet_03v3 ad=10p pd=21u as=10p ps=21u w=20u l=1u
X553 lo_bq_Ny2 lo_bq_Ny1 VDD VDD pfet_03v3 ad=1.25p pd=3.5u as=2.5p ps=7u w=2.5u l=0.28u
X554 bbq_t1 bq_n bbq_o1p VSS nfet_03v3 ad=10p pd=21u as=10p ps=21u w=20u l=1u
X555 lna_tail nb VSS VSS nfet_03v3 ad=5p pd=11u as=2.8p ps=10.56u w=10u l=0.5u
X556 VSS b_nr VSS ppolyf_u r_width=2u r_length=29.72u
X557 VSS en lo_bq_Pgs VSS nfet_03v3 ad=1p pd=4u as=0.28p ps=1.56u w=1u l=0.28u
X558 li_cb li_gcn li_ct VSS nfet_03v3 ad=1p pd=3u as=1p ps=3u w=2u l=0.5u
X559 VDD lq_lp VSS ppolyf_u r_width=1u r_length=28.56u
X560 bbi_o1p bbi_g2p bbi_o1p bbi_o1p pfet_03v3 ad=6.1425p pd=13.285u as=0 ps=0 w=12.285u l=10u
X561 VSS bi_n VSS VSS nfet_03v3 ad=3.6855p pd=17.28u as=0 ps=0 w=8.19u l=5u
X562 bbi_t1 bi_p bbi_o1n VSS nfet_03v3 ad=10p pd=21u as=10p ps=21u w=20u l=1u
X563 VSS bbq_o2n VSS VSS nfet_03v3 ad=12.285p pd=25.57u as=0 ps=0 w=24.57u l=10u
X564 lna_x2i_tail lna_outn ri_p VSS nfet_03v3 ad=5p pd=11u as=5p ps=11u w=10u l=0.28u
X565 oq_n bbq_g3p bbq_t3 VSS nfet_03v3 ad=4p pd=10u as=2p ps=5u w=4u l=1u
X566 lq_cb lq_cb VDD VDD pfet_03v3 ad=1p pd=4u as=0.45p ps=2.9u w=1u l=0.5u
X567 bbi_t3 nb VSS VSS nfet_03v3 ad=0.8p pd=3.6u as=0.36p ps=2.5u w=0.8u l=0.5u
X568 lna_outp inn lna_tail VSS nfet_03v3 ad=5p pd=11u as=5p ps=11u w=10u l=0.28u
X569 ri_n VDD VSS ppolyf_u r_width=2u r_length=9.14u
X570 bbi_vgr nb VSS VSS nfet_03v3 ad=0.42p pd=2.84u as=0.42p ps=2.84u w=0.42u l=50u
X571 bbi_t1 bi_p bbi_o1n VSS nfet_03v3 ad=10p pd=21u as=10p ps=21u w=20u l=1u
X572 bbq_o1p bq_n bbq_t1 VSS nfet_03v3 ad=10p pd=21u as=10p ps=21u w=20u l=1u
X573 bbq_o1p bq_n bbq_t1 VSS nfet_03v3 ad=10p pd=21u as=10p ps=21u w=20u l=1u
X574 lq_ln lq_gcn lq_ln lq_ln pfet_03v3 ad=12.285p pd=26.57u as=24.57p ps=53.14u w=12.285u l=10u
X575 VSS lq_vb VSS VSS nfet_03v3 ad=5.52825p pd=25.47u as=0 ps=0 w=12.285u l=10u
X576 bbi_o1p bi_n bbi_t1 VSS nfet_03v3 ad=10p pd=21u as=10p ps=21u w=20u l=1u
X577 VSS oq_p VSS VSS nfet_03v3 ad=12.285p pd=25.57u as=0 ps=0 w=24.57u l=10u
X578 lna_outn inp lna_tail VSS nfet_03v3 ad=5p pd=11u as=5p ps=11u w=10u l=0.28u
X579 VDD li_lp VSS ppolyf_u r_width=1u r_length=28.56u
X580 bbi_vb VSS VSS ppolyf_u_1k r_width=1u r_length=99.99u
X581 lna_outp inn lna_tail VSS nfet_03v3 ad=5p pd=11u as=5p ps=11u w=10u l=0.28u
X582 VSS bi_n VSS VSS nfet_03v3 ad=2.2932p pd=8.75u as=0 ps=0 w=8.19u l=5u
X583 VSS VDD VSS VSS nfet_03v3 ad=5.4p pd=24.9u as=0 ps=0 w=12u l=10u
X584 bbq_t1 bq_n bbq_o1p VSS nfet_03v3 ad=10p pd=21u as=10p ps=21u w=20u l=1u
C0 oi_p VDD 1.70229f
C1 lo_bi_tb ls 0.03717f
C2 lo_bi_Py1 bi_p 0
C3 lo_lq_D1x lsq 0.65684f
C4 VDD lo_bq_t 0.53509f
C5 lq_ln nb 0.42806f
C6 lq_gln lq_ln 0.99875f
C7 bbi_g3n bbi_o2n 6.81759f
C8 oi_n bbi_vgr 6.2003f
C9 bi_p nb 0.09552f
C10 b_n2 b_vh 2.80573f
C11 li_ca li_lp 0.95018f
C12 oq_p VDD 1.90898f
C13 lo_bq_Py1 lo_bq_Py2 2.44938f
C14 lo_bi_x lo_bi_t 1.7784f
C15 bbq_g2p oq_n 0.23654f
C16 lo_bi_t bi_n 0
C17 bbi_o1p bbi_g2p 4.53819f
C18 bbi_vbt bi_n 0.00951f
C19 bbi_g3p bbi_t3 2.91775f
C20 bbi_t2 bbi_g3n 0
C21 li_ca li_cx 0.19538f
C22 q_i nb 0.11424f
C23 oi_p li_vbt 0.42476f
C24 lq_cb nb 0.10392f
C25 VDD b_vh 1.31067f
C26 lo_bq_b en 2.94909f
C27 oi_n VDD 2.10664f
C28 lq_co lq_gcn 0.00689f
C29 bbq_o2p bbq_t3 0
C30 bbq_vgr bbq_g2p 0.18549f
C31 aq lo_lq_lg 1.98512f
C32 VDD li_mRpCb 0.13847f
C33 enb bbi_vbt 0.62326f
C34 bbq_mRp2a bbq_o2p 0.02666f
C35 lo_bi_Py0 lo_i 0.53184f
C36 bbi_vgr VDD 8.70759f
C37 VDD b_n2 1.60615f
C38 VDD bbq_o1p 1.62549f
C39 li_gcn li_co 0.00689f
C40 bbq_t1 bbq_o2n 0.48555f
C41 lo_lq_vq lo_lq_lg 0.33992f
C42 li_gcn li_vb 2.44488f
C43 bbi_vb bbi_t3 0.14106f
C44 VDD lo_bq_a 0.76152f
C45 lo_bq_Py0 lo_bq_Py1 1.276f
C46 lsq en 1.88825f
C47 bbi_mRp2a bbi_o1n 0.04266f
C48 bbi_o2p bbi_g2n 4.3121f
C49 bq_n lo_i 0.00182f
C50 li_ca nb 0.15947f
C51 lo_lq_lf a_48024_1776# 0
C52 bbq_o1p bq_p 0.43338f
C53 rq_n lna_x2q_tail 3.85225f
C54 bbq_mRp2a bbq_o1n 0.04266f
C55 lo_bi_Py0 ls 0.0923f
C56 bbq_g3n bbq_t3 2.927f
C57 bbq_mRp2b bbq_o2n 0.00107f
C58 aq lo_lq_lf 0.00489f
C59 bbi_t3 nb 2.98191f
C60 li_mRpLb VDD 0.03387f
C61 lq_mRpCa lq_mRpCb 0.76885f
C62 lq_mRpCa lq_vb 0.98733f
C63 bbi_t1 bbi_g2n 0.01151f
C64 en lo_bq_ta 0.07314f
C65 lo_bi_Py0 bi_p 0
C66 bbq_o2p bbq_mRp3a 0.03426f
C67 lq_vb lq_mRpLb 0.73361f
C68 lo_bi_Py1 lo_bi_a 0
C69 VDD bq_p 1.47274f
C70 lq_ln lq_glp 2.62696f
C71 lo_bi_x lob_i 0.08182f
C72 bbi_o1n bbi_vb 0.18862f
C73 li_vbt VDD 0.67806f
C74 lob_i bi_n 1.99701f
C75 lo_lq_vq lo_lq_lf 3.23667f
C76 lna_tail lna_outn 25.3551f
C77 lq_mRpCa nb 1.82097f
C78 enb oq_n 0.15529f
C79 lq_mRpLb nb 0.09398f
C80 lq_gln lq_mRpLb 0.60267f
C81 bq_n ls 0.05175f
C82 lq_ln lq_vbt 0.88479f
C83 bbi_mRp2b bbi_g2p 0.62517f
C84 lo_bq_Ny2 en 0
C85 lna_outp lna_x2q_tail 7.58093f
C86 bbq_o2p bbq_t2 0.3005f
C87 lo_bq_Pgs lsq 0.00248f
C88 bq_n bi_p 0
C89 li_vgr li_mRpLa 0.15699f
C90 bbi_vgr bbi_vbt 0.08774f
C91 lna_tail nb 18.5174f
C92 bbi_o1n nb 0.02579f
C93 lq_lp oq_n 0.18927f
C94 lo_bq_b lo_bq_x 0.06191f
C95 enb rq_n 0
C96 bbi_t3 bbi_g3n 2.927f
C97 lq_cb lq_vbt 0.00161f
C98 en lo_bq_Py2 0.7223f
C99 bbq_g3n bbq_mRp3a 0.1479f
C100 bbi_mRp2a bbi_vb 3.04322f
C101 en ri_p 0.0945f
C102 bbi_g3p bbi_vb 0.83647f
C103 lo_bi_t VDD 0.5349f
C104 VDD bbi_vbt 1.66897f
C105 lna_vcm rq_p 0.24483f
C106 q_q lq_cb 0
C107 bbq_mRp2a bbq_vbt 0.00601f
C108 lo_lq_D1x lo_lq_q1 0
C109 bbq_g3n bbq_t2 0
C110 lo_bi_Py2 en 0.72059f
C111 lsq lo_bq_x 1.38153f
C112 li_ln li_gcn 4.21834f
C113 lo_bi_Pgs lo_i 0
C114 oq_p oq_n 11.9991f
C115 enb lna_outp 0
C116 lo_lq_lo1 lsq 0.12133f
C117 bbi_g3p nb 0.17164f
C118 bbi_g2n bi_n 0.02783f
C119 lo_bq_b lo_bq_tb 0.80645f
C120 li_lp nb 0.15624f
C121 bbi_g3p bbi_mRp3a 2.77518f
C122 bbq_vgr oq_p 0.90342f
C123 lo_bq_Py0 en 0.73089f
C124 lo_bq_x lo_bq_ta 0
C125 lo_bi_a lo_bi_Py0 1.46313f
C126 bbq_o1p oq_n 0.00139f
C127 VDD li_cq 0.3678f
C128 lo_bi_Pgs ls 0.00248f
C129 li_lp li_gln 4.11236f
C130 bbq_mRp2a bbq_mRp2b 0.14576f
C131 aq VDD 0
C132 lsq lo_bq_tb 0.03717f
C133 lq_vb lq_mRpCb 0.39812f
C134 lq_mRpLb lq_glp 0.10842f
C135 bbi_vb nb 2.5559f
C136 bbq_vgr bbq_o1p 0.31673f
C137 li_gcn li_gcp 1.16018f
C138 bbi_vb bbi_mRp3a 0.68743f
C139 li_vgr q_i 0.11145f
C140 lna_outn nb 4.11094f
C141 VDD oq_n 2.27427f
C142 nb lq_mRpCb 0.01135f
C143 oi_p bbi_g2n 0.06647f
C144 lo_bi_Py1 nb 0
C145 VDD lo_lq_vq 1.60425f
C146 lq_vb nb 4.64825f
C147 lq_gln lq_vb 2.65772f
C148 bbi_g3p bbi_g3n 0.34872f
C149 VDD lob_i 1.73305f
C150 lq_mRpCa q_q 0.062f
C151 lo_lq_D1y lo_lq_lf 0
C152 bbq_vgr VDD 8.70759f
C153 lq_gln nb 0.20704f
C154 enb li_gcn 0.00488f
C155 lo_bq_Pgs lo_bq_Py0 0.07271f
C156 lo_q lo_bq_g0s 0
C157 bbq_t1 bbq_t2 0.003f
C158 bq_p oq_n 0.01544f
C159 VDD rq_n 4.53069f
C160 lna_vt enb 0.39792f
C161 bbq_g2p bbq_o2n 3.24838f
C162 oi_n bbi_g2n 0.17948f
C163 bbi_vb bbi_g3n 0.60573f
C164 li_gln nb 0.20704f
C165 bbq_vgr bq_p 0.00137f
C166 lo_bq_Ny2 ri_n 0
C167 bbq_g3p bbq_g2p 0.01549f
C168 bbi_vgr bbi_g2n 1.6135f
C169 bq_p rq_n 3.75152f
C170 VDD lna_outp 5.31192f
C171 lob_q rq_p 1.13241f
C172 nb bbi_g3n 0.27085f
C173 lo_bq_b lo_bq_Ny0 1.41643f
C174 inn lna_vcm 3.43594f
C175 bbi_mRp3a bbi_g3n 0.1479f
C176 ri_n ri_p 6.62475f
C177 lq_cb lq_co 0
C178 lq_ca lq_gcn 3.24031f
C179 VDD bbi_g2n 1.86961f
C180 bbi_o2p bbi_g2p 2.6676f
C181 lo_lq_D1qb lsq 1.76399f
C182 bbi_o1p bbi_o2n 0.0821f
C183 lo_bi_t lob_i 0.09542f
C184 lo_bi_Py1 lo_bi_Py0 1.276f
C185 li_gcn li_mRpCb 0.54081f
C186 lo_lq_vq a_48450_713# 0.00409f
C187 lo_bi_a lo_bi_Pgs 0.00896f
C188 lq_cx lq_gcn 0.01262f
C189 lo_q bq_n 1.23189f
C190 lna_x2i_tail ri_p 4.02866f
C191 lo_bi_Py0 nb 0
C192 lq_vb lq_glp 3.18848f
C193 lob_q en 0.08077f
C194 bbi_t1 bbi_g2p 0.01205f
C195 bbq_vb nb 2.5559f
C196 lq_vb lq_vbt 0.94378f
C197 nb lq_glp 0.15007f
C198 lq_gln lq_glp 0.84592f
C199 b_x en 0.03867f
C200 enb bbq_o2n 0.78638f
C201 lo_bi_Py1 bq_n 0
C202 lna_vcm ri_n 3.33651f
C203 li_cb q_i 0
C204 nb lq_vbt 0.12882f
C205 lq_gln lq_vbt 0.37516f
C206 q_q lq_vb 0.24451f
C207 lq_vgr lq_gcn 3.17454f
C208 VDD li_gcn 1.69492f
C209 lo_lq_D1y VDD 0
C210 bq_n nb 1.47527f
C211 lo_lq_vq a_48024_1776# 0.23085f
C212 bbi_o1p bi_p 0.43338f
C213 q_q nb 0.11424f
C214 b_nr nb 2.47068f
C215 aq lo_lq_vq 0.03342f
C216 inp ri_p 0
C217 lna_vt VDD 0.26026f
C218 nb bbq_g2n 0.07879f
C219 li_vgr li_lp 0.12743f
C220 bbq_mRp2a bbq_g2p 2.71538f
C221 lo_bq_Ny2 lo_bq_Ny0 0.00506f
C222 ri_p lo_i 1.12024f
C223 lna_vcm lna_x2i_tail 0.00759f
C224 a_47706_713# lo_lq_vq 0.00198f
C225 lo_lq_lo2 lsq 0.96379f
C226 li_ct li_ca 0.33596f
C227 bbq_vgr oq_n 6.2003f
C228 li_vbt li_gcn 0
C229 rq_p lna_x2q_tail 4.09819f
C230 lo_bi_Py2 lo_i 3.02187f
C231 bbi_mRp2b bbi_o2n 0.00107f
C232 li_cb li_ca 1.75008f
C233 en lo_bq_Ngs 0.00905f
C234 oq_p bbq_o2n 2.54324f
C235 lq_mRpLa lq_ln 0.05545f
C236 oq_p bbq_g3p 1.08101f
C237 bbi_g2p bi_n 0.02671f
C238 lna_vcm inp 0.28752f
C239 lq_tL lq_ln 0.51422f
C240 ri_p bi_p 2.29294f
C241 enb bbi_g2p 0.00127f
C242 li_vgr nb 0.35015f
C243 lob_q lo_bq_x 0.08182f
C244 ls lo_bi_Py2 0.67392f
C245 bbq_o1p bbq_o2n 0.0821f
C246 bq_n lo_bi_Py0 0
C247 enb rq_p 7.78755f
C248 lo_bi_Py2 bi_p 0
C249 bbq_g2p bbq_t2 2.90297f
C250 VDD lo_lq_tt 0.00269f
C251 lq_cq lq_gcn 0
C252 lo_lq_D1y a_48450_713# 0.07136f
C253 li_vgr li_gln 2.26794f
C254 lq_glp lq_vbt 0.87545f
C255 VDD bbq_o2n 1.75028f
C256 rq_n lna_outp 4.85285f
C257 bbq_vb bbq_g2n 0.51815f
C258 lo_bi_x lo_bi_ta 0
C259 oi_p bbi_g2p 0.10829f
C260 VDD bbq_g3p 4.33045f
C261 lo_bq_a lo_bq_Py1 0
C262 lo_bi_ta bi_n 0
C263 lo_lq_D1qb lo_lq_q1 0.74328f
C264 lo_bi_x en 0.54597f
C265 lob_q lo_bq_tb 0.48724f
C266 en bi_n 0.01115f
C267 VDD lo_bq_Py1 0.56507f
C268 lo_bi_Ny1 bi_n 0
C269 li_mRpCa q_i 0.062f
C270 lo_lq_D1y a_48024_1776# 0.00509f
C271 li_cq li_gcn 0
C272 bq_n bbq_g2n 0.02783f
C273 bq_p bbq_o2n 1.03194f
C274 bbi_o1p bbi_o1n 6.02565f
C275 lq_gcp lq_gcn 1.16018f
C276 enb en 6.53665f
C277 li_ct li_lp 0.00147f
C278 enb lo_bi_Ny1 0
C279 lq_ct lq_gcn 0.61274f
C280 oi_n bbi_g2p 0.23654f
C281 li_cb li_lp 0.8057f
C282 a_47706_713# lo_lq_D1y 0.01134f
C283 lo_lq_D1y lo_lq_vq 0.51666f
C284 li_vb li_mRpLa 1.00198f
C285 lo_q lo_bq_b 0.13724f
C286 oq_p bbq_t3 0.49853f
C287 li_cb li_cx 0.17701f
C288 bbi_vgr bbi_g2p 0.18549f
C289 lq_mRpLa lq_mRpLb 0.08841f
C290 lo_bq_Ny1 lo_bq_b 0.00411f
C291 enb lq_gcn 0.00488f
C292 en lo_bq_t 1.04581f
C293 bbq_vb bbq_mRp3b 0.42363f
C294 VDD lo_lq_D1x 0
C295 lo_bi_Pgs lo_bi_Py0 0.07271f
C296 lq_ca lq_ln 0.33477f
C297 lo_lq_lo1 lo_lq_lg 0.20859f
C298 VDD bbi_g2p 2.40668f
C299 lo_q lsq 0.09369f
C300 lna_vt rq_n 0.13876f
C301 lo_bi_a lo_bi_Py2 0
C302 li_ct nb 0.94367f
C303 lq_lp lq_gcn 0.00459f
C304 VDD rq_p 2.73002f
C305 en b_vh 0.00139f
C306 li_cb nb 0.10392f
C307 bbi_o1p bbi_vb 0.14015f
C308 lq_ca lq_cb 1.75008f
C309 oq_p bbq_mRp3a 2.19053f
C310 bbq_mRp2a VDD 0.04832f
C311 lo_q lo_bq_ta 0.10101f
C312 lo_bi_Ny0 bi_n 0
C313 lo_bq_g0s lo_bq_b 0
C314 en b_n2 0.18292f
C315 bbq_o2p nb 0.04002f
C316 rq_p bq_p 2.20237f
C317 lq_cx lq_cb 0.17701f
C318 en lo_bq_a 1.31385f
C319 lq_vgr lq_ln 2.69553f
C320 lo_lq_lo1 lo_lq_lf 0.00642f
C321 enb lo_bi_Ny0 0
C322 lob_q lo_bq_Ny0 0.5145f
C323 bbi_o2p bbi_o2n 4.9399f
C324 oq_p bbq_t2 0.47994f
C325 lo_bi_ta VDD 0.33628f
C326 bbi_o1p nb 0
C327 lna_tail lna_vcm 0.60498f
C328 q_i li_co 0.02598f
C329 VDD en 4.00146f
C330 lo_bi_x lo_bi_b 0.06191f
C331 lo_bi_Ny1 VDD 0.58954f
C332 q_i li_vb 0.24451f
C333 lo_lq_tt lo_lq_vq 0.16377f
C334 bbq_o2n oq_n 1.58613f
C335 lo_bi_b bi_n 0
C336 lo_bq_Ny1 lo_bq_Ny2 2.32672f
C337 lo_bq_g0s lsq 0.00494f
C338 bbi_t2 bbi_o2p 0.3005f
C339 bbq_o1n nb 0.02579f
C340 enb lo_bi_b 0
C341 bbq_g3p oq_n 3.04668f
C342 bbi_t1 bbi_o2n 0.48555f
C343 bbi_mRp2b bbi_mRp2a 0.14576f
C344 bbq_vgr bbq_o2n 1.51266f
C345 li_glp li_mRpLa 2.72864f
C346 li_ln li_mRpLa 0.05545f
C347 bbi_vbt bbi_g2p 1.35765f
C348 lo_q lo_bq_Py2 3.02187f
C349 ri_n bi_n 1.44397f
C350 bbq_mRp3a VDD 0.1197f
C351 lo_bq_x lo_bq_t 1.7784f
C352 en bq_p 4.62352f
C353 bbq_g3n nb 0.27085f
C354 lo_lq_D1x a_48450_713# 0.00911f
C355 bbq_vgr bbq_g3p 0.17684f
C356 q_q lq_co 0.02598f
C357 lq_mRpLa lq_vb 1.00198f
C358 VDD lq_gcn 1.69489f
C359 enb ri_n 0.07869f
C360 lna_outn ri_p 6.25655f
C361 bbi_t1 bbi_t2 0.003f
C362 lo_bq_Pgs lo_bq_a 0.00896f
C363 bbi_o2p bi_p 1.0729f
C364 li_ca li_co 0.34422f
C365 lq_mRpLa nb 0.13287f
C366 lq_gln lq_mRpLa 0.14083f
C367 bbi_mRp2b bbi_vb 0.57255f
C368 lo_bq_Ngs lo_bq_Ny0 0.07147f
C369 lo_bq_Pgs VDD 0
C370 ri_p nb 0.9629f
C371 lo_lq_D1x a_48024_1776# 0.14135f
C372 lq_tL nb 0.95043f
C373 lo_bi_Py1 lo_bi_Py2 2.44938f
C374 lq_gln lq_tL 0.66214f
C375 lo_q lo_bq_Py0 0.53184f
C376 lo_bi_ta lo_bi_t 1.27093f
C377 bbi_t1 bi_p 15.0185f
C378 lo_bq_tb lo_bq_t 1.34876f
C379 bbq_o2p bbq_vb 1.28735f
C380 lo_bi_Py2 nb 0
C381 lo_bi_Ny2 bi_n 0
C382 lo_bi_t en 1.04578f
C383 lo_bq_x lo_bq_a 0
C384 bq_n lsq 0.0525f
C385 enb lo_bi_Ny2 0
C386 lna_vcm lna_outn 2.71659f
C387 lo_lq_vq lo_lq_D1x 0.26831f
C388 li_mRpCa nb 1.82097f
C389 lq_mRpCa lq_vgr 0.15699f
C390 bbq_o2p bq_n 1.11728f
C391 lq_vgr lq_mRpLb 1.38037f
C392 inn VDD 0.51493f
C393 bbi_o2n bi_n 0.99043f
C394 VDD lo_bq_x 0.38375f
C395 VDD lo_bi_Ny0 0.36895f
C396 lo_bi_x lo_i 0.06208f
C397 lo_i bi_n 1.27603f
C398 bbi_mRp3b bbi_g3p 0.14588f
C399 lna_vcm nb 6.11363f
C400 bbq_t1 nb 0.70522f
C401 bbq_o2p bbq_g2n 4.3121f
C402 lo_lq_lo1 VDD 0
C403 bbq_o1n bbq_vb 0.18862f
C404 enb bbi_o2n 0.78638f
C405 bbq_t3 oq_n 0.87498f
C406 lq_cb lq_cq 0
C407 lo_lq_D1qb lo_lq_lf 0.00156f
C408 lq_gcp lq_ln 2.31969f
C409 bbq_g3n bbq_vb 0.60573f
C410 bbi_o2p bbi_t3 0
C411 lo_bi_b VDD 1.52213f
C412 bbq_o1n bq_n 0.54853f
C413 rq_p rq_n 3.6498f
C414 lq_ct lq_ln 0.12331f
C415 bbi_mRp3b bbi_vb 0.42363f
C416 bbq_mRp2a bbq_vgr 0.05312f
C417 lo_bi_x ls 1.38153f
C418 ls bi_n 0
C419 lo_lq_lo2 lo_lq_lg 0.00588f
C420 VDD lo_bq_tb 1.55527f
C421 bbq_o1n bbq_g2n 6.65711f
C422 oi_p bbi_o2n 2.54324f
C423 VDD ri_n 4.43941f
C424 lq_mRpLa lq_glp 2.72864f
C425 lq_cb lq_gcp 0.40553f
C426 lo_bi_ta lob_i 0.02078f
C427 lo_bi_x bi_p 0
C428 bi_p bi_n 24.878f
C429 li_lp li_vb 0.23236f
C430 enb lq_ln 0.10666f
C431 li_co li_cx 0.28525f
C432 lq_mRpLa lq_vbt 0.07167f
C433 en lob_i 0.0809f
C434 lq_tL lq_glp 0.64021f
C435 li_ca li_ln 0.33477f
C436 lo_bi_Py0 lo_bi_Py2 0
C437 lq_ct lq_cb 0.22508f
C438 q_i li_gcp 0.05927f
C439 lo_bi_Ny1 lob_i 0.20682f
C440 enb bi_p 0.84143f
C441 bq_n lo_bq_Py2 0.00141f
C442 rq_p lna_outp 0.13055f
C443 bbi_o2p bbi_o1n 0.37415f
C444 oi_p bbi_t2 0.47994f
C445 bbi_g2n bbi_g2p 4.72021f
C446 bbi_mRp3b bbi_mRp3a 0.08704f
C447 lq_ca nb 0.15947f
C448 bbq_mRp3a oq_n 0.00909f
C449 VDD lna_x2i_tail 0.44747f
C450 lo_bi_x lo_bi_g0s 0.03739f
C451 lq_lp lq_ln 0.86658f
C452 oi_n bbi_o2n 1.58613f
C453 bbq_vbt bbq_vb 0.28747f
C454 enb lq_cb 0.00333f
C455 bq_n lo_bi_Py2 0.00133f
C456 bbq_vgr bbq_mRp3a 0.05207f
C457 oq_n bbq_t2 1.43221f
C458 bbi_t1 bbi_o1n 10.899f
C459 lo_lq_lo2 lo_lq_lf 0
C460 VDD lo_bi_Ngs 0.00217f
C461 bbi_vgr bbi_o2n 1.51266f
C462 VDD lo_bi_Ny2 0.916f
C463 lo_lq_lo1 a_48450_713# 0
C464 VDD li_mRpLa 0.21658f
C465 lo_bi_b lo_bi_t 0.21425f
C466 oi_n bbi_t2 1.43221f
C467 lq_vgr lq_mRpCb 0.03293f
C468 lo_q lob_q 2.59148f
C469 bbq_vgr bbq_t2 0
C470 bbq_vbt bq_n 0.00951f
C471 li_ca li_gcp 1.11631f
C472 bbi_mRp2a bbi_o2p 0.02666f
C473 lq_vgr lq_vb 9.55397f
C474 bbi_o2p bbi_g3p 5.93947f
C475 lq_lp lq_cb 0.8057f
C476 nb li_vb 4.64825f
C477 lo_lq_D1y lo_lq_D1x 0.88042f
C478 bbi_mRp3b bbi_g3n 0.50302f
C479 oq_p lq_ln 0.48261f
C480 VDD inp 0.43429f
C481 lo_bq_Ny1 lob_q 0.20682f
C482 bbq_g3n bbq_mRp3b 0.50302f
C483 bbi_vgr bbi_t2 0
C484 bq_n bbq_t1 15.1293f
C485 VDD bbi_o2n 1.75028f
C486 li_mRpLb li_mRpLa 0.08841f
C487 lq_vgr nb 0.35015f
C488 lq_gln lq_vgr 2.26794f
C489 lq_mRpCa lq_gcp 0.45829f
C490 VDD lo_i 2.35959f
C491 enb li_ca 0.00985f
C492 li_gln li_vb 2.65772f
C493 li_vbt li_mRpLa 0.07167f
C494 bbq_mRp2b bbq_vb 0.57255f
C495 oi_n bi_p 0.01544f
C496 bbq_t1 bbq_g2n 0.01151f
C497 lo_lq_D1qb VDD 0
C498 bbi_o2p bbi_vb 1.28735f
C499 bbq_g3p bbq_o2n 0.12772f
C500 lna_vt rq_p 0.0591f
C501 b_x nb 2.18179f
C502 lo_bi_x lo_bi_a 0
C503 bbi_vgr bi_p 0.00137f
C504 lo_bi_a bi_n 0
C505 bq_p lo_i 0.01838f
C506 VDD lo_bq_Ny0 0.36906f
C507 lo_bi_Ny0 lob_i 0.5145f
C508 VDD ls 0.35761f
C509 lo_lq_lo1 lo_lq_vq 0.28227f
C510 li_glp li_lp 0.74628f
C511 li_ln li_lp 0.86658f
C512 li_ct li_cb 0.22508f
C513 bbq_mRp2b bbq_g2n 0.62129f
C514 VDD lq_ln 1.63445f
C515 lo_bq_g0s lob_q 0.00261f
C516 bbi_o2p nb 0.04002f
C517 bbi_o1n bi_n 0.54853f
C518 lo_bq_b lsq 1.6034f
C519 VDD bi_p 4.28848f
C520 li_mRpCa li_vgr 0.15699f
C521 bbi_o2p bbi_mRp3a 0.03426f
C522 oi_p bbi_t3 0.49853f
C523 lq_ca lq_vbt 0.02106f
C524 lna_tail enb 0
C525 lo_bi_b lob_i 0.25839f
C526 enb bbi_o1n 0.32203f
C527 ls bq_p 0.04785f
C528 VDD q_i 1.58452f
C529 q_q lq_ca 0.0045f
C530 VDD lq_cb 1.08903f
C531 bbi_t1 nb 0.70522f
C532 lo_bi_t lo_i 0.28918f
C533 bbq_g2p nb 0.07889f
C534 bq_p bi_p 0
C535 lq_vb lq_cq 0.00355f
C536 VDD lo_bi_g0s 0
C537 ri_n lob_i 1.05507f
C538 inn lna_outp 21.4308f
C539 lo_bq_b lo_bq_ta 0.06137f
C540 VDD lo_lq_lo2 0
C541 li_lp li_gcp 2.0507f
C542 lq_cx q_q 0.00495f
C543 oi_n bbi_t3 0.87498f
C544 lna_outn lna_x2q_tail 8.15728f
C545 li_glp nb 0.15007f
C546 li_cx li_gcp 0
C547 lq_vgr lq_glp 0.11821f
C548 bbi_o2p bbi_g3n 0.19553f
C549 li_ln nb 0.42806f
C550 li_tL li_lp 0.40988f
C551 lq_vgr lq_vbt 0.76002f
C552 lo_lq_D1qb a_48450_713# 0.0061f
C553 lna_x2q_tail nb 6.97815f
C554 enb li_lp 0.05f
C555 lo_bi_t ls 0.09656f
C556 lsq lo_bq_ta 0.29598f
C557 lq_gcp lq_mRpCb 0.14475f
C558 li_glp li_gln 0.84592f
C559 lq_vb lq_gcp 0.47644f
C560 VDD li_ca 0.90676f
C561 li_ln li_gln 0.99875f
C562 bbq_t3 bbq_o2n 0.30481f
C563 q_q lq_vgr 0.11145f
C564 lo_bi_Ngs lob_i 0.00392f
C565 lob_q bq_n 1.95104f
C566 bbq_o2p bbq_o1n 0.37415f
C567 lo_bi_t bi_p 0
C568 bbq_t3 bbq_g3p 2.91775f
C569 lq_gcp nb 0.94136f
C570 lq_gln lq_gcp 0
C571 lo_bi_Ny2 lob_i 4.35651f
C572 bbi_vbt bi_p 0.00152f
C573 oi_n bbi_o1n 0.00225f
C574 ri_n lna_outp 2.32216f
C575 lo_lq_D1qb a_48024_1776# 0.01794f
C576 bbq_o2p bbq_g3n 0.19553f
C577 lq_ct nb 0.94367f
C578 oi_p bbi_g3p 1.08101f
C579 lo_bi_Py1 bi_n 0
C580 oi_p li_lp 0.15192f
C581 nb li_gcp 0.94136f
C582 bbi_vgr bbi_o1n 2.7789f
C583 li_vbt li_ca 0.02106f
C584 VDD lq_mRpCa 0.16896f
C585 b_nr b_x 0.01134f
C586 enb lna_outn 0
C587 lo_bi_a VDD 0.76132f
C588 VDD lq_mRpLb 0.03387f
C589 li_tL nb 0.95043f
C590 lo_bi_x lo_bi_tb 0.17958f
C591 lo_bi_t lo_bi_g0s 0
C592 nb bi_n 7.33556f
C593 lo_i lob_i 2.62395f
C594 lsq lo_bq_Py2 0.6764f
C595 a_47706_713# lo_lq_D1qb 0.07726f
C596 lo_lq_D1y lo_lq_lo1 0
C597 lna_x2i_tail lna_outp 5.04918f
C598 li_gln li_gcp 0
C599 enb nb 48.1835f
C600 lo_lq_D1qb lo_lq_vq 0.59062f
C601 enb lq_gln 0.01156f
C602 lna_tail VDD 0.284f
C603 lo_bq_Py0 lo_bq_b 0.17687f
C604 VDD bbi_o1n 1.62614f
C605 en lo_bq_Py1 0.12284f
C606 oi_p bbi_vb 1.61419f
C607 bbq_vb bbq_g2p 0.66867f
C608 li_vgr li_vb 9.55397f
C609 li_tL li_gln 0.66214f
C610 lo_q lo_bq_t 0.28918f
C611 oi_n bbi_g3p 3.04668f
C612 lq_lp lq_vb 0.23236f
C613 oi_n li_lp 0.18927f
C614 enb li_gln 0.01156f
C615 lq_ln oq_n 0.93324f
C616 bbi_mRp2a bbi_vgr 0.05312f
C617 lq_lp nb 0.15624f
C618 lq_lp lq_gln 4.11236f
C619 bbq_mRp3a bbq_g3p 2.77518f
C620 bq_n bbq_g2p 0.02671f
C621 ls lob_i 0.58091f
C622 bbi_vgr bbi_g3p 0.17684f
C623 li_cq q_i 1.44037f
C624 lo_bq_Py0 lsq 0.0923f
C625 inp lna_outp 0.58906f
C626 bbq_o2n bbq_t2 0.56895f
C627 oi_p nb 1.97217f
C628 bi_p lob_i 1.29033f
C629 oi_n bbi_vb 0.33016f
C630 bbq_g2p bbq_g2n 4.72021f
C631 bbq_g3p bbq_t2 0.01189f
C632 oi_p bbi_mRp3a 2.19053f
C633 lo_bq_Ny2 ri_p 0
C634 lq_ca lq_co 0.34422f
C635 q_q lq_cq 1.44037f
C636 bbi_mRp2a VDD 0.04832f
C637 VDD bbi_g3p 4.33045f
C638 bbq_o2p bbq_t1 0.41474f
C639 VDD li_lp 1.6706f
C640 oi_p li_gln 0.30002f
C641 bbi_g2n bbi_o2n 0.63356f
C642 bbi_vgr bbi_vb 8.98949f
C643 oq_p nb 1.70903f
C644 oq_p lq_gln 0.30002f
C645 lo_bi_a lo_bi_t 0.00509f
C646 VDD li_cx 0.26162f
C647 lq_gcp lq_glp 0
C648 lq_cx lq_co 0.28525f
C649 lo_bi_g0s lob_i 0.00261f
C650 lo_q lo_bq_a 0.47966f
C651 bbq_vbt bbq_o1n 1.19688f
C652 lq_gcp lq_vbt 0.00317f
C653 oi_n nb 5.01967f
C654 nb b_vh 0.784f
C655 lo_lq_vq lo_lq_lo2 0.39275f
C656 lo_bi_Py0 bi_n 0
C657 lo_bq_g0s lo_bq_t 0
C658 lsq lo_lq_q1 0.04689f
C659 li_ca li_cq 0
C660 bbi_t2 bbi_g2n 2.93218f
C661 oi_n bbi_mRp3a 0.00909f
C662 li_mRpCb nb 0.01135f
C663 lo_q VDD 2.36371f
C664 bbi_vbt bbi_o1n 1.19688f
C665 VDD bbi_vb 5.61364f
C666 bbq_o2p bbq_mRp2b 0.58102f
C667 q_q lq_gcp 0.05927f
C668 bbq_o1n bbq_t1 10.899f
C669 oi_p bbi_g3n 3.27704f
C670 li_vbt li_lp 0.14942f
C671 bbi_vgr nb 2.29375f
C672 b_n2 nb 3.63931f
C673 bbq_o1p nb 0
C674 VDD lna_outn 0.98822f
C675 oi_n li_gln 2.16225f
C676 lo_bq_Ny1 VDD 0.58962f
C677 bbi_vgr bbi_mRp3a 0.05207f
C678 VDD lq_mRpCb 0.13847f
C679 lo_bi_Py1 VDD 0.565f
C680 VDD lq_vb 5.48011f
C681 enb lq_glp 0.00176f
C682 bq_n bi_n 0
C683 lo_q bq_p 2.23159f
C684 enb lq_vbt 0.99337f
C685 lo_bi_tb VDD 1.55495f
C686 VDD nb 11.5727f
C687 VDD lq_gln 1.67595f
C688 bbi_g2n bi_p 0.02054f
C689 lo_bq_Py0 lo_bq_Py2 0
C690 enb bq_n 0.32081f
C691 li_vgr li_glp 0.11821f
C692 VDD bbi_mRp3a 0.1197f
C693 li_vgr li_ln 2.69553f
C694 oi_n bbi_g3n 0.10389f
C695 lo_bi_ta en 0.07312f
C696 lq_lp lq_glp 0.74628f
C697 b_nr enb 0.04735f
C698 lo_lq_D1y lo_lq_D1qb 0.74379f
C699 lna_vcm ri_p 0.05223f
C700 bbi_mRp2a bbi_vbt 0.00601f
C701 lo_bi_Py1 bq_p 0
C702 li_mRpLb nb 0.09398f
C703 li_cb li_co 0
C704 VDD li_gln 1.67595f
C705 lo_bi_Ny1 en 0.00102f
C706 lq_lp lq_vbt 0.14942f
C707 bbi_vgr bbi_g3n 0.06347f
C708 bq_p nb 0.11175f
C709 bbq_t3 bbq_t2 0.00372f
C710 lo_bi_a lob_i 0.0038f
C711 li_vbt nb 0.12882f
C712 lob_q lo_bq_b 0.25839f
C713 lo_bq_g0s VDD 0
C714 li_mRpLb li_gln 0.60267f
C715 oq_p bbq_vb 1.61419f
C716 oq_p lq_glp 2.16317f
C717 bbi_vbt bbi_vb 0.28747f
C718 VDD bbi_g3n 3.79046f
C719 li_vbt li_gln 0.37516f
C720 bbq_vbt bbq_t1 0.00159f
C721 li_vgr li_gcp 3.10457f
C722 oq_p lq_vbt 0.42476f
C723 lo_lq_lo1 lo_lq_D1x 0
C724 lob_q lsq 0.58091f
C725 li_gcn q_i 0.0493f
C726 lo_bq_Pgs en 0.00905f
C727 bbq_vb bbq_o1p 0.14015f
C728 oq_p bbq_g2n 0.06647f
C729 lo_bi_tb lo_bi_t 1.34876f
C730 lo_bi_t nb 0
C731 li_cq li_cx 0
C732 lq_co lq_cq 1.35725f
C733 b_nr b_vh 0.04885f
C734 VDD lo_bi_Py0 0.35449f
C735 lo_lq_D1y lo_lq_lo2 0.003f
C736 bq_n bbq_o1p 15.6107f
C737 VDD bbq_vb 5.61364f
C738 lob_q lo_bq_ta 0.02078f
C739 lo_bq_b lo_bq_Ngs 0.00888f
C740 VDD lq_glp 1.20118f
C741 lna_tail lna_outp 24.5656f
C742 b_nr b_n2 1.21756f
C743 bbq_o1p bbq_g2n 0.02964f
C744 VDD lq_vbt 0.67806f
C745 VDD bq_n 0.56333f
C746 lob_q lo_bq_Ny2 4.35651f
C747 en lo_bq_x 0.54597f
C748 lo_bi_Py0 bq_p 0
C749 li_ca li_gcn 3.24031f
C750 en lo_bi_Ny0 0.81999f
C751 bbi_o1p bbi_o2p 0.17851f
C752 bbi_o1n bbi_g2n 6.65711f
C753 li_ct li_ln 0.12331f
C754 lo_bi_Ny1 lo_bi_Ny0 1.27426f
C755 VDD q_q 1.58462f
C756 lq_mRpLa lq_vgr 0.15699f
C757 b_nr VDD 0.56081f
C758 VDD bbq_g2n 1.86961f
C759 li_cb li_ln 0.24663f
C760 lo_bi_ta lo_bi_b 0.06137f
C761 oq_p bbq_mRp3b 1.22474f
C762 bbq_o2p bbq_g2p 2.6676f
C763 lo_bi_b en 2.94909f
C764 bq_n bq_p 18.0956f
C765 lo_q rq_n 1.14054f
C766 bbi_o1p bbi_t1 10.4824f
C767 nb oq_n 6.77501f
C768 lo_bi_Ny1 lo_bi_b 0.00411f
C769 lq_gln oq_n 2.16225f
C770 oi_n li_vgr 0
C771 li_mRpCa li_vb 0.98733f
C772 li_vgr li_mRpCb 0.03293f
C773 lna_outn rq_n 0.20838f
C774 bq_p bbq_g2n 0.02054f
C775 lo_bi_tb lob_i 0.48724f
C776 lo_bq_tb en 0.06062f
C777 lsq lo_lq_lg 0
C778 bbq_vgr nb 2.2874f
C779 bbi_mRp2a bbi_g2n 0.13427f
C780 bbi_g3p bbi_g2n 0.00924f
C781 en ri_n 0.60495f
C782 li_ct li_gcp 0.95309f
C783 bbq_o1n bbq_g2p 2.57561f
C784 rq_n nb 3.87899f
C785 bbi_o2n bbi_g2p 3.24838f
C786 li_cb li_gcp 0.40553f
C787 VDD li_vgr 1.93315f
C788 VDD bbq_mRp3b 0.14807f
C789 li_ct enb 0.05233f
C790 lo_lq_D1qb lo_lq_D1x 0.70987f
C791 lna_outn lna_outp 3.56533f
C792 bbi_g2n bbi_vb 0.51815f
C793 bbi_t2 bbi_g2p 2.90297f
C794 bbi_mRp2b bbi_o2p 0.58102f
C795 li_cb enb 0.00333f
C796 VDD lo_bi_Pgs 0
C797 li_mRpLb li_vgr 1.38037f
C798 lna_outp nb 0.32997f
C799 lo_bi_Ngs en 0.00905f
C800 lsq lo_lq_lf 0.33461f
C801 en lo_bi_Ny2 0
C802 lq_cx lq_ca 0.19538f
C803 lo_bi_Ny1 lo_bi_Ny2 2.32672f
C804 li_vbt li_vgr 0.76002f
C805 li_lp li_gcn 0.00459f
C806 bbq_o2p enb 0.79436f
C807 bbi_o1p bi_n 15.6107f
C808 li_gcn li_cx 0.01262f
C809 bbi_g2n nb 0.07879f
C810 lo_bq_b lo_bq_t 0.21425f
C811 lo_bi_ta lo_i 0.10101f
C812 bi_p bbi_g2p 0.01844f
C813 bbi_o1p enb 0.20141f
C814 bbq_vb oq_n 0.33016f
C815 lo_bi_b lo_bi_Ny0 1.41643f
C816 en lo_i 0.47012f
C817 lq_glp oq_n 0.1613f
C818 bbq_vbt bbq_g2p 1.35765f
C819 bbq_vgr bbq_vb 8.98949f
C820 enb bbq_o1n 0.32203f
C821 bq_n oq_n 0.01688f
C822 lsq lo_bq_t 0.09656f
C823 lo_bq_tb lo_bq_x 0.17958f
C824 inn ri_n 0
C825 bbq_t1 bbq_g2p 0.01205f
C826 VDD lq_co 0.40432f
C827 lo_lq_D1x lo_lq_lo2 0.08987f
C828 lo_bi_ta ls 0.29598f
C829 en lo_bq_Ny0 0.81999f
C830 oq_n bbq_g2n 0.17948f
C831 li_gcn nb 0.46544f
C832 ls en 5.26976f
C833 bbq_o2p oq_p 0.29088f
C834 lo_bi_ta bi_p 0
C835 lo_bq_b lo_bq_a 2.81922f
C836 bq_n rq_n 1.44397f
C837 bbq_vgr bbq_g2n 1.6135f
C838 inn lna_x2i_tail 0
C839 ri_p bi_n 1.5904f
C840 lna_vt nb 0.12457f
C841 lna_vcm lna_x2q_tail 0.00345f
C842 lo_bq_t lo_bq_ta 1.27093f
C843 en bi_p 0.27035f
C844 bbq_mRp2b bbq_g2p 0.62517f
C845 li_gcn li_gln 0
C846 lo_bi_Ny1 bi_p 0
C847 VDD lo_bq_b 1.52233f
C848 enb ri_p 0.05585f
C849 lo_bi_Py2 bi_n 0
C850 bbi_o1p oi_n 0.00139f
C851 lo_bi_Ngs lo_bi_Ny0 0.07147f
C852 li_mRpCa li_gcp 0.45829f
C853 lo_bi_Ny2 lo_bi_Ny0 0.00506f
C854 bbq_o2p bbq_o1p 0.17851f
C855 li_cb VDD 1.08916f
C856 lsq lo_bq_a 0.15892f
C857 lq_ln lq_gcn 4.21834f
C858 en lo_bi_g0s 0.00471f
C859 bbi_o1p bbi_vgr 0.31673f
C860 inn inp 8.71578f
C861 lq_lp lq_tL 0.40988f
C862 VDD lsq 1.76264f
C863 bbq_g3n oq_p 3.27704f
C864 bbq_o2p VDD 2.48834f
C865 lo_bi_b lo_bi_Ngs 0.00888f
C866 bbq_vbt enb 0.62326f
C867 ri_n lna_x2i_tail 3.91883f
C868 lq_ca lq_cq 0
C869 li_cb li_vbt 0.00161f
C870 bbi_o1p VDD 1.62549f
C871 lq_cb lq_gcn 1.53463f
C872 lna_vcm enb 2.73623f
C873 bbq_o1n bbq_o1p 6.02565f
C874 enb bbq_t1 0.21873f
C875 lo_bq_ta lo_bq_a 1.27941f
C876 bbq_vgr bbq_mRp3b 0.0027f
C877 bbi_o1n bbi_g2p 2.57561f
C878 lsq bq_p 0.89094f
C879 lq_cx lq_cq 0
C880 VDD lo_bq_ta 0.33639f
C881 lo_lq_lo1 lo_lq_D1qb 0
C882 oq_p lq_tL 0.00244f
C883 bbq_o2p bq_p 1.0729f
C884 lo_q lo_bq_Py1 0.14534f
C885 lo_bi_b lo_i 0.13724f
C886 bbq_o1n VDD 1.62614f
C887 lo_lq_lf lo_lq_q1 0
C888 bbq_o2n nb 0.53721f
C889 VDD lo_bq_Ny2 0.91604f
C890 lq_ca lq_gcp 1.11631f
C891 bbq_g3n VDD 3.79046f
C892 li_ln li_vb 0.22387f
C893 li_glp li_vb 3.18848f
C894 lo_bi_a lo_bi_ta 1.27941f
C895 bbq_g3p nb 0.17164f
C896 lq_ct lq_ca 0.33596f
C897 lob_q lo_bq_Ngs 0.00392f
C898 lo_bi_a en 1.31385f
C899 ri_n lo_i 1.14054f
C900 bi_p lo_bi_Ny0 0
C901 lo_bq_a lo_bq_Py2 0
C902 lq_cx lq_gcp 0
C903 bbi_g3p bbi_g2p 0.01549f
C904 bbi_mRp2a bbi_g2p 2.71538f
C905 bbq_o1n bq_p 9.18763f
C906 VDD lq_mRpLa 0.21658f
C907 lo_bi_b ls 1.6034f
C908 inp lna_x2i_tail 0
C909 VDD lo_bq_Py2 0.84617f
C910 bbi_mRp2b bbi_vgr 0.00978f
C911 VDD ri_p 3.67067f
C912 li_mRpCa li_mRpCb 0.76885f
C913 VDD lq_tL 0.15562f
C914 enb lq_ca 0.00985f
C915 lo_bq_tb lo_bq_Ny0 0.06857f
C916 lo_bi_b bi_p 0
C917 a_48450_713# lsq 0.01348f
C918 bbi_t1 bbi_o2p 0.41474f
C919 lq_mRpCa lq_gcn 0.26877f
C920 bbi_o1p bbi_vbt 1.6832f
C921 bbq_vbt bbq_o1p 1.6832f
C922 VDD lo_bi_Py2 0.84617f
C923 lq_vgr lq_gcp 3.10457f
C924 bbi_vb bbi_g2p 0.66867f
C925 li_vb li_gcp 0.47644f
C926 bbi_mRp2b VDD 1.27896f
C927 lo_lq_lo1 lo_lq_lo2 1.04229f
C928 bq_p lo_bq_Py2 0.00487f
C929 lo_bq_Py0 lo_bq_a 1.46313f
C930 lq_lp lq_ca 0.95018f
C931 bbq_o1p bbq_t1 10.4824f
C932 ri_n bi_p 3.73479f
C933 li_cb li_cq 0
C934 lo_q rq_p 1.12024f
C935 oi_p bbi_mRp3b 1.22474f
C936 bbq_vbt VDD 1.66897f
C937 li_mRpCa VDD 0.16896f
C938 lo_bq_Py0 VDD 0.35459f
C939 lo_bi_b lo_bi_g0s 0
C940 rq_p lna_outn 8.87469f
C941 lsq a_48024_1776# 0.02603f
C942 lo_bi_Py2 bq_p 0.00967f
C943 nb bbi_g2p 0.07889f
C944 lna_vcm VDD 0.90371f
C945 VDD bbq_t1 0.46847f
C946 li_vgr li_gcn 3.17454f
C947 bbq_vb bbq_o2n 0.35264f
C948 rq_p nb 0.49764f
C949 bbq_vbt bq_p 0.00152f
C950 a_47706_713# lsq 0.01386f
C951 bbi_t2 bbi_o2n 0.56895f
C952 bbq_vb bbq_g3p 0.83647f
C953 lo_lq_vq lsq 2.05308f
C954 bbq_o2p oq_n 1.56807f
C955 bbq_t3 nb 2.98191f
C956 lo_q en 0.49285f
C957 lq_lp lq_vgr 0.12743f
C958 lo_bi_Ny2 bi_p 0
C959 bq_n bbq_o2n 0.99043f
C960 bq_p bbq_t1 15.0185f
C961 b_x enb 0.45325f
C962 bbq_mRp2b VDD 1.27896f
C963 li_glp li_ln 2.62696f
C964 bbi_mRp3b bbi_vgr 0.0027f
C965 bbq_vgr bbq_o2p 0.23215f
C966 lo_bq_Ny1 en 0.00107f
C967 bbi_o2p bi_n 1.11728f
C968 inn lna_tail 21.6972f
C969 ls lo_i 0.09108f
C970 bbq_o2n bbq_g2n 0.63356f
C971 lo_bi_Py1 en 0.12279f
C972 lo_bi_ta nb 0
C973 bi_p bbi_o2n 1.03194f
C974 enb bbi_o2p 0.79436f
C975 bbq_g3p bbq_g2n 0.00924f
C976 bbq_o1n oq_n 0.00225f
C977 lo_bi_a lo_bi_b 2.81922f
C978 lo_i bi_p 2.27136f
C979 en nb 0.67458f
C980 lo_bi_tb en 0.06062f
C981 lob_q lo_bq_t 0.09542f
C982 bbi_mRp3b VDD 0.14807f
C983 lo_bi_Ny1 nb 0
C984 VDD lq_ca 0.9067f
C985 bbq_g3n oq_n 0.10389f
C986 bbq_vgr bbq_o1n 2.7789f
C987 bbi_t1 bi_n 15.1293f
C988 li_mRpCb li_vb 0.39812f
C989 lq_mRpCb lq_gcn 0.54081f
C990 enb bbi_t1 0.21873f
C991 li_ln li_gcp 2.31969f
C992 lq_vb lq_gcn 2.44488f
C993 li_glp li_gcp 0
C994 lo_bq_Pgs lo_q 0
C995 bbq_vgr bbq_g3n 0.06347f
C996 VDD lq_cx 0.26162f
C997 lo_i lo_bi_g0s 0
C998 enb bbq_g2p 0.00127f
C999 oi_p bbi_o2p 0.29088f
C1000 li_tL li_glp 0.64021f
C1001 lo_bq_g0s en 0.00471f
C1002 li_tL li_ln 0.51422f
C1003 ls bi_p 0
C1004 nb lq_gcn 0.46544f
C1005 lq_gln lq_gcn 0
C1006 VDD li_co 0.40418f
C1007 lq_tL oq_n 0.77929f
C1008 enb li_glp 0.00176f
C1009 b_x b_vh 1.54113f
C1010 enb li_ln 0.10666f
C1011 lo_lq_D1qb lo_lq_lo2 0.02485f
C1012 nb bbq_t2 2.83595f
C1013 VDD li_vb 5.48011f
C1014 ri_p lob_i 1.13241f
C1015 lo_lq_lg lo_lq_lf 0.22692f
C1016 lq_ct lq_gcp 0.95309f
C1017 bbi_o1p bbi_g2n 0.02964f
C1018 VDD lq_vgr 1.93315f
C1019 li_ct li_gcn 0.61274f
C1020 bbq_t3 bbq_vb 0.14106f
C1021 bbq_mRp3b bbq_g3p 0.14588f
C1022 lq_cb lq_ln 0.24663f
C1023 lob_q lo_bq_a 0.0038f
C1024 ls lo_bi_g0s 0.00494f
C1025 b_x b_n2 0.42354f
C1026 li_mRpLb li_vb 0.73361f
C1027 oi_n bbi_o2p 1.56807f
C1028 lo_q lo_bq_x 0.06208f
C1029 bq_n rq_p 1.5904f
C1030 bbq_mRp2a bbq_vb 3.04322f
C1031 li_cb li_gcn 1.53463f
C1032 lob_q VDD 1.73717f
C1033 bbi_t3 bbi_o2n 0.30481f
C1034 inn lna_outn 1.4769f
C1035 li_vbt li_vb 0.94378f
C1036 enb lq_gcp 0.00536f
C1037 oi_p li_glp 2.16317f
C1038 oi_p li_ln 0.48261f
C1039 bbi_vgr bbi_o2p 0.23215f
C1040 b_x VDD 0.90637f
C1041 lo_bi_Py0 en 0.73089f
C1042 oq_p bbq_g2p 0.10829f
C1043 bbq_vgr bbq_vbt 0.08774f
C1044 lo_bi_x bi_n 0
C1045 bbq_t1 oq_n 0.00386f
C1046 lo_lq_D1y lsq 1.40306f
C1047 enb lq_ct 0.05233f
C1048 bbi_t2 bbi_t3 0.00372f
C1049 oi_n bbi_t1 0.00386f
C1050 enb li_gcp 0.00536f
C1051 inn nb 0.84533f
C1052 lob_q bq_p 1.24465f
C1053 lo_bi_a lo_i 0.47966f
C1054 lo_bi_Ny0 nb 0
C1055 lq_lp lq_gcp 2.0507f
C1056 lo_bi_tb lo_bi_Ny0 0.06857f
C1057 bbq_mRp2a bbq_g2n 0.13427f
C1058 ri_p lna_outp 0.18626f
C1059 enb bi_n 0.45995f
C1060 bbq_vgr bbq_t1 0.03745f
C1061 lna_tail inp 18.8461f
C1062 VDD bbi_o2p 2.48834f
C1063 bbi_vgr bbi_t1 0.03745f
C1064 lq_lp lq_ct 0.00147f
C1065 bq_n en 0.05314f
C1066 lo_q lo_bq_tb 0.00378f
C1067 lo_bi_Py1 lo_bi_b 0
C1068 bbi_o1n bbi_o2n 0.38655f
C1069 oi_n li_glp 0.1613f
C1070 oi_n li_ln 0.93324f
C1071 lna_vcm rq_n 0.43052f
C1072 bbq_o1p bbq_g2p 4.53819f
C1073 bbq_mRp3a bbq_vb 0.68743f
C1074 lo_lq_vq lo_lq_q1 0.21914f
C1075 b_nr en 0.08089f
C1076 lo_bi_tb lo_bi_b 0.80645f
C1077 lna_outn ri_n 0.34015f
C1078 lo_bq_g0s lo_bq_x 0.03739f
C1079 bbq_vgr bbq_mRp2b 0.00978f
C1080 bbi_t1 VDD 0.46847f
C1081 lo_bi_a ls 0.15892f
C1082 li_ca q_i 0.0045f
C1083 oi_p li_tL 0.00244f
C1084 VDD lo_bq_Ngs 0.00217f
C1085 lq_lp enb 0.05f
C1086 VDD bbq_g2p 2.40668f
C1087 bbi_mRp2b bbi_g2n 0.62129f
C1088 lq_vbt lq_gcn 0
C1089 ri_n nb 0.99456f
C1090 lo_bi_a bi_p 0
C1091 lna_vcm lna_outp 0.37213f
C1092 oi_p enb 0.07459f
C1093 VDD lq_cq 0.3678f
C1094 VDD li_glp 1.20118f
C1095 q_q lq_gcn 0.0493f
C1096 lna_outn lna_x2i_tail 5.79198f
C1097 VDD li_ln 1.63445f
C1098 bbi_g3p bbi_o2n 0.12772f
C1099 VDD lo_lq_lg 0.00201f
C1100 bq_p bbq_g2p 0.01844f
C1101 bbi_o1n bi_p 9.18763f
C1102 VDD lna_x2q_tail 0.44326f
C1103 li_cq li_co 1.35725f
C1104 li_mRpCb li_gcp 0.14475f
C1105 bbq_g2n bbq_t2 2.93218f
C1106 li_cq li_vb 0.00355f
C1107 enb oq_p 0.13239f
C1108 li_tL oi_n 0.77929f
C1109 oi_n bi_n 0.01688f
C1110 li_mRpLb li_glp 0.10842f
C1111 lo_bq_b lo_bq_Py1 0
C1112 lna_x2i_tail nb 4.58476f
C1113 bbi_t2 bbi_g3p 0.01189f
C1114 lo_lq_tt lsq 0.83329f
C1115 enb oi_n 0.6238f
C1116 li_vbt li_glp 0.87545f
C1117 enb b_vh 0.25355f
C1118 li_vbt li_ln 0.88479f
C1119 VDD lq_gcp 1.65299f
C1120 bbq_o2p bbq_o2n 4.9399f
C1121 bbi_vb bbi_o2n 0.35264f
C1122 lna_outn inp 18.4613f
C1123 lo_bi_Ny2 nb 0
C1124 lq_lp oq_p 0.15192f
C1125 enb bbi_vgr 0.00769f
C1126 nb li_mRpLa 0.13287f
C1127 li_mRpCa li_gcn 0.26877f
C1128 VDD li_gcp 1.6543f
C1129 lq_vgr oq_n 0
C1130 bbq_o2p bbq_g3p 5.93947f
C1131 enb b_n2 0.11728f
C1132 lo_bi_Pgs en 0.00905f
C1133 enb bbq_o1p 0.20141f
C1134 lsq lo_bq_Py1 0.44552f
C1135 bbi_t1 bbi_vbt 0.00159f
C1136 lo_bi_x VDD 0.38366f
C1137 lo_bi_b lo_bi_Py0 0.17687f
C1138 li_tL VDD 0.15562f
C1139 lo_bi_Py1 lo_i 0.14534f
C1140 inp nb 0.23145f
C1141 VDD bi_n 1.16732f
C1142 VDD lo_lq_lf 0.0017f
C1143 bbq_mRp3a bbq_mRp3b 0.08704f
C1144 nb bbi_o2n 0.53721f
C1145 oi_p oi_n 10.4495f
C1146 li_gln li_mRpLa 0.14083f
C1147 enb VDD 13.4644f
C1148 lo_bi_tb lo_i 0.00378f
C1149 bbq_o1n bbq_o2n 0.38655f
C1150 lna_vt lna_vcm 0.07779f
C1151 lo_bq_Ny1 lo_bq_Ny0 1.27426f
C1152 li_vbt li_gcp 0.00317f
C1153 oi_p bbi_vgr 0.90342f
C1154 bbq_g3n bbq_o2n 6.81759f
C1155 bq_p bi_n 0
C1156 bbi_t2 nb 2.83595f
C1157 q_i li_cx 0.00495f
C1158 lob_q rq_n 1.05507f
C1159 lo_lq_D1y lo_lq_q1 0.00721f
C1160 lo_bi_Py1 ls 0.44552f
C1161 lq_lp VDD 1.6706f
C1162 bbq_g3n bbq_g3p 0.34872f
C1163 lq_vb lq_ln 0.22387f
C1164 enb bq_p 0.39919f
C1165 lo_bq_t lo_bq_a 0.00509f
C1166 enb li_vbt 0.99337f
C1167 aq VSS 4.5261f
C1168 inn VSS 7.74055f
C1169 inp VSS 8.6135f
C1170 ls VSS 6.44886f
C1171 en VSS 26.6322f
C1172 q_q VSS 4.33525f
C1173 q_i VSS 4.33535f
C1174 VDD VSS 1.17987p
C1175 a_48450_713# VSS 0.14599f
C1176 a_47706_713# VSS 0.14869f
C1177 lo_lq_lg VSS 1.43421f
C1178 lo_lq_lo1 VSS 0.65273f
C1179 lo_lq_D1x VSS 0.56779f
C1180 a_48024_1776# VSS 0.01195f
C1181 lo_lq_tt VSS 0.3924f
C1182 lo_lq_q1 VSS 0.35733f
C1183 lo_lq_D1y VSS 0.53224f
C1184 lo_lq_D1qb VSS 1.02163f
C1185 lo_lq_lo2 VSS 0.69056f
C1186 lna_x2q_tail VSS 6.46619f
C1187 lna_vt VSS 0.67237f
C1188 lo_lq_lf VSS 7.527f
C1189 rq_n VSS 9.89192f
C1190 rq_p VSS 9.44928f
C1191 lna_tail VSS 23.7494f
C1192 lo_bq_Pgs VSS 0.10589f
C1193 lo_bq_g0s VSS 0.06752f
C1194 lo_bq_Ngs VSS 0.10696f
C1195 lo_q VSS 3.28457f
C1196 lo_bq_Py0 VSS 0.79732f
C1197 lo_bq_a VSS 1.53489f
C1198 lsq VSS 9.52141f
C1199 lo_bq_x VSS 0.76481f
C1200 lo_bq_Py1 VSS 1.17572f
C1201 lo_bq_ta VSS 0.8476f
C1202 lo_bq_b VSS 2.08198f
C1203 lo_bq_Ny0 VSS 0.84813f
C1204 lo_bq_tb VSS 1.17359f
C1205 lo_bq_Ny1 VSS 1.1181f
C1206 lo_bq_t VSS 1.2788f
C1207 lna_vcm VSS 24.5691f
C1208 lna_x2i_tail VSS 6.56898f
C1209 lna_outn VSS 11.3951f
C1210 lna_outp VSS 12.3584f
C1211 lob_q VSS 3.87574f
C1212 lo_bq_Py2 VSS 1.6314f
C1213 lo_bq_Ny2 VSS 1.67776f
C1214 ri_n VSS 9.25097f
C1215 b_vh VSS 1.07541f
C1216 ri_p VSS 10.1904f
C1217 lo_bi_Pgs VSS 0.10589f
C1218 lo_bi_g0s VSS 0.06752f
C1219 lo_bi_Ngs VSS 0.10696f
C1220 b_nr VSS 1.4407f
C1221 b_n2 VSS 2.66748f
C1222 b_x VSS 1.85733f
C1223 lo_i VSS 3.28558f
C1224 lo_bi_Py0 VSS 0.79737f
C1225 lo_bi_a VSS 1.535f
C1226 lo_bi_x VSS 0.76485f
C1227 lo_bi_Py1 VSS 1.17574f
C1228 lo_bi_ta VSS 0.84765f
C1229 lo_bi_b VSS 2.08208f
C1230 lo_bi_Ny0 VSS 0.84818f
C1231 lo_bi_tb VSS 1.17359f
C1232 lo_bi_Ny1 VSS 1.11812f
C1233 lo_bi_t VSS 1.27885f
C1234 lob_i VSS 3.87676f
C1235 lo_bi_Py2 VSS 1.62624f
C1236 lo_bi_Ny2 VSS 1.67769f
C1237 bbq_t3 VSS 2.88763f
C1238 bbq_t2 VSS 2.48721f
C1239 bbq_t1 VSS 4.88036f
C1240 bq_n VSS 24.8208f
C1241 bbi_t3 VSS 2.88763f
C1242 bbi_t2 VSS 2.48721f
C1243 bq_p VSS 22.1666f
C1244 bbi_t1 VSS 4.88036f
C1245 bi_n VSS 27.4935f
C1246 bi_p VSS 28.586f
C1247 bbq_mRp3b VSS 0.70445f
C1248 bbq_mRp3a VSS 0.87833f
C1249 bbq_mRp2b VSS 0.92869f
C1250 bbq_mRp2a VSS 0.74262f
C1251 bbq_vgr VSS 14.9963f
C1252 bbi_mRp3b VSS 0.70445f
C1253 bbi_mRp3a VSS 0.87833f
C1254 bbi_mRp2b VSS 0.92869f
C1255 bbi_mRp2a VSS 0.74262f
C1256 bbi_vgr VSS 15.0005f
C1257 bbq_vbt VSS 1.69129f
C1258 bbi_vbt VSS 1.69129f
C1259 lq_ct VSS 0.51595f
C1260 lq_tL VSS 0.58536f
C1261 li_ct VSS 0.51595f
C1262 li_tL VSS 0.58536f
C1263 lq_co VSS 0.91906f
C1264 lq_cx VSS 1.19827f
C1265 lq_ca VSS 2.01286f
C1266 lq_cb VSS 1.40895f
C1267 lq_cq VSS 0.83872f
C1268 li_co VSS 0.91919f
C1269 li_cx VSS 1.19827f
C1270 li_ca VSS 2.01279f
C1271 li_cb VSS 1.40882f
C1272 li_cq VSS 0.83872f
C1273 enb VSS 46.9225f
C1274 lq_mRpCb VSS 0.7771f
C1275 lq_mRpCa VSS 0.84957f
C1276 lq_mRpLb VSS 1.72501f
C1277 lq_mRpLa VSS 0.89621f
C1278 li_mRpCb VSS 0.7771f
C1279 li_mRpCa VSS 0.84957f
C1280 li_mRpLb VSS 1.72501f
C1281 li_mRpLa VSS 0.89621f
C1282 lq_vgr VSS 8.62119f
C1283 lq_vbt VSS 1.12351f
C1284 li_vgr VSS 8.6227f
C1285 nb VSS 0.15772p
C1286 li_vbt VSS 1.12351f
C1287 lo_lq_vq VSS 45.6631f
C1288 bbq_o2n VSS 68.2533f
C1289 bbq_o2p VSS 65.827f
C1290 bbq_o1n VSS 48.1919f
C1291 bbq_o1p VSS 42.8538f
C1292 bbi_o2n VSS 68.2533f
C1293 bbi_o2p VSS 65.827f
C1294 bbi_o1n VSS 48.1919f
C1295 bbi_o1p VSS 42.8538f
C1296 bbq_g3n VSS 8.5093f
C1297 bbq_g3p VSS 7.11958f
C1298 bbq_g2n VSS 8.075f
C1299 bbq_g2p VSS 8.10695f
C1300 bbq_vb VSS 63.1562f
C1301 bbi_g3n VSS 8.5093f
C1302 bbi_g3p VSS 7.11958f
C1303 bbi_g2n VSS 8.075f
C1304 bbi_g2p VSS 8.10695f
C1305 bbi_vb VSS 63.1562f
C1306 lq_ln VSS 26.3767f
C1307 lq_lp VSS 23.7524f
C1308 oq_p VSS 56.8282f
C1309 oq_n VSS 54.2393f
C1310 li_ln VSS 26.3767f
C1311 li_lp VSS 23.7524f
C1312 oi_p VSS 55.6623f
C1313 oi_n VSS 53.5558f
C1314 lq_gcn VSS 5.0031f
C1315 lq_gcp VSS 6.82863f
C1316 lq_gln VSS 4.45907f
C1317 lq_glp VSS 4.34318f
C1318 lq_vb VSS 66.65579f
C1319 li_gcn VSS 5.00307f
C1320 li_gcp VSS 6.82732f
C1321 li_gln VSS 4.45907f
C1322 li_glp VSS 4.34318f
C1323 li_vb VSS 66.65579f
.ends
