* rx_top: magic R+C extraction of layout/rx_top.gds (layout/gen/pex.sh)
* extracted 2026-11-15T23:54:34+01:00 with magic 8.3.642, mode c, from rx_top.gds
.subckt rx_top VDD VSS inp inn ls aq en q_i q_q
X0 lna_x2i_tail lna_outn ri_p VSS nfet_03v3 ad=5p pd=11u as=5p ps=11u w=10u l=0.28u
X1 lna_vt lna_vcm VSS ppolyf_u_1k r_width=1u r_length=40u
X2 VDD oq_p VSS ppolyf_u_1k r_width=1u r_length=0.2m
X3 li_cx li_cb VDD VDD pfet_03v3 ad=2p pd=6u as=0.9p ps=4.9u w=2u l=0.5u
X4 VSS VDD VSS VSS nfet_03v3 ad=3.36p pd=12.56u as=1.59357n ps=4.15258m w=12u l=10u
X5 lo_bi_ta lo_bi_t VDD VDD pfet_03v3 ad=1.25p pd=4.5u as=1.25p ps=4.5u w=1.25u l=0.28u
X6 VSS bbq_o2p VSS VSS nfet_03v3 ad=24.57p pd=51.14u as=0 ps=0 w=24.57u l=10u
X7 VSS bbi_o2n VSS VSS nfet_03v3 ad=24.57p pd=51.14u as=0 ps=0 w=24.57u l=10u
X8 bbi_mRp3b bbi_mRp3b bbi_vb bbi_vb pfet_03v3 ad=0.42p pd=2.84u as=0.42p ps=2.84u w=0.42u l=1u
X9 bi_n lob_i ri_n VDD pfet_03v3 ad=8p pd=17u as=8p ps=17u w=16u l=0.28u
X10 bbq_t1 bq_p bbq_o1n VSS nfet_03v3 ad=10p pd=21u as=10p ps=21u w=20u l=1u
X11 VSS VDD VSS VSS nfet_03v3 ad=3.36p pd=12.56u as=0 ps=0 w=12u l=10u
X12 lna_outn inp lna_tail VSS nfet_03v3 ad=5p pd=11u as=5p ps=11u w=10u l=0.28u
X13 lsq lo_lq_lo2 VSS VSS nfet_03v3 ad=1.2p pd=4.4u as=0.54p ps=3.3u w=1.2u l=0.28u
X14 bbi_t1 bi_p bbi_o1n VSS nfet_03v3 ad=10p pd=21u as=10p ps=21u w=20u l=1u
X15 VSS bq_p VSS VSS nfet_03v3 ad=2.2932p pd=8.75u as=0 ps=0 w=8.19u l=5u
X16 lo_bq_ta lo_bq_t VDD VDD pfet_03v3 ad=1.25p pd=4.5u as=1.25p ps=4.5u w=1.25u l=0.28u
X17 lna_x2i_tail lna_outp ri_n VSS nfet_03v3 ad=5p pd=11u as=10p ps=22u w=10u l=0.28u
X18 VSS nb lna_tail VSS nfet_03v3 ad=2.8p pd=10.56u as=5p ps=11u w=10u l=0.5u
X19 oq_n lq_gln oq_n oq_n pfet_03v3 ad=12.285p pd=26.57u as=24.57p ps=53.14u w=12.285u l=10u
X20 bbq_vb VSS VSS ppolyf_u_1k r_width=1u r_length=99.99u
X21 rq_n lna_outp lna_x2q_tail VSS nfet_03v3 ad=5p pd=11u as=5p ps=11u w=10u l=0.28u
X22 VSS VDD VSS VSS nfet_03v3 ad=3.36p pd=12.56u as=0 ps=0 w=12u l=10u
X23 lo_bi_Py1 lo_bi_Py0 VDD VDD pfet_03v3 ad=2p pd=6u as=2p ps=6u w=2u l=0.28u
X24 bbq_o1p bq_n bbq_t1 VSS nfet_03v3 ad=10p pd=21u as=10p ps=21u w=20u l=1u
X25 li_lp li_gcp li_lp li_lp pfet_03v3 ad=12.285p pd=26.57u as=24.57p ps=53.14u w=12.285u l=10u
X26 lq_ct nb VSS VSS nfet_03v3 ad=2p pd=6u as=0.9p ps=4.9u w=2u l=0.5u
X27 lo_bq_a lo_bq_b VSS VSS nfet_03v3 ad=0.42p pd=2.84u as=0.42p ps=2.84u w=0.42u l=0.28u
X28 VSS nb VSS VSS nfet_03v3 ad=4.095p pd=9.19u as=0 ps=0 w=8.19u l=10u
X29 lo_bq_Py1 lo_bq_Py0 VDD VDD pfet_03v3 ad=2p pd=6u as=2p ps=6u w=2u l=0.28u
X30 lo_bi_Py2 lo_bi_Py1 VSS VSS nfet_03v3 ad=2p pd=6u as=2p ps=6u w=2u l=0.28u
X31 bbi_t3 bbi_g3p oi_n VSS nfet_03v3 ad=2p pd=5u as=4p ps=10u w=4u l=1u
X32 VSS nb lna_tail VSS nfet_03v3 ad=2.8p pd=10.56u as=5p ps=11u w=10u l=0.5u
X33 VSS VDD VSS VSS nfet_03v3 ad=3.36p pd=12.56u as=0 ps=0 w=12u l=10u
X34 VSS oq_n VSS VSS nfet_03v3 ad=12.285p pd=25.57u as=0 ps=0 w=24.57u l=10u
X35 bbq_vbt enb VDD VDD pfet_03v3 ad=1p pd=4u as=0.45p ps=2.9u w=1u l=0.28u
X36 rq_n lo_q bq_p VDD pfet_03v3 ad=8p pd=17u as=8p ps=17u w=16u l=0.28u
X37 VDD lo_bi_Ny1 lo_bi_Ny2 VDD pfet_03v3 ad=2.5p pd=7u as=1.25p ps=3.5u w=2.5u l=0.28u
X38 VSS nb bbq_t1 VSS nfet_03v3 ad=3.6p pd=16.9u as=4p ps=9u w=8u l=0.5u
X39 VSS nb lna_tail VSS nfet_03v3 ad=4.5p pd=20.9u as=5p ps=11u w=10u l=0.5u
X40 li_mRpLb li_mRpLb li_vb li_vb pfet_03v3 ad=0.42p pd=2.84u as=0.42p ps=2.84u w=0.42u l=1u
X41 bbi_o1n bi_p bbi_t1 VSS nfet_03v3 ad=10p pd=21u as=10p ps=21u w=20u l=1u
X42 lo_bi_Pgs lo_bi_a lo_bi_Py0 VSS nfet_03v3 ad=0.28p pd=1.56u as=1p ps=4u w=1u l=0.28u
X43 lsq lo_lq_lo2 lo_lq_vq lo_lq_vq pfet_03v3 ad=3p pd=8u as=1.35p ps=6.9u w=3u l=0.28u
X44 VDD lo_bq_Ny1 lo_bq_Ny2 VDD pfet_03v3 ad=2.5p pd=7u as=1.25p ps=3.5u w=2.5u l=0.28u
X45 lo_bi_b VDD lo_bi_tb VSS nfet_03v3 ad=1p pd=4u as=1p ps=4u w=1u l=0.28u
X46 rq_n lna_outp lna_x2q_tail VSS nfet_03v3 ad=5p pd=11u as=5p ps=11u w=10u l=0.28u
X47 lna_tail inn lna_outp VSS nfet_03v3 ad=5p pd=11u as=5p ps=11u w=10u l=0.28u
X48 bbi_o1n bi_p bbi_t1 VSS nfet_03v3 ad=20p pd=42u as=10p ps=21u w=20u l=1u
X49 bbq_t1 bq_p bbq_o1n VSS nfet_03v3 ad=10p pd=21u as=10p ps=21u w=20u l=1u
X50 VSS bbi_o2p VSS VSS nfet_03v3 ad=12.285p pd=25.57u as=0 ps=0 w=24.57u l=10u
X51 li_vbt enb VDD VDD pfet_03v3 ad=1p pd=4u as=0.45p ps=2.9u w=1u l=0.28u
X52 li_vgr nb VSS VSS nfet_03v3 ad=0.42p pd=2.84u as=0.42p ps=2.84u w=0.42u l=50u
X53 VSS lq_vb VSS VSS nfet_03v3 ad=3.4398p pd=12.845u as=0 ps=0 w=12.285u l=10u
X54 bbq_mRp3b bbq_mRp3b bbq_g3n bbq_g3n pfet_03v3 ad=0.42p pd=2.84u as=0.42p ps=2.84u w=0.42u l=1u
X55 lna_tail inp lna_outn VSS nfet_03v3 ad=5p pd=11u as=5p ps=11u w=10u l=0.28u
X56 bbq_o2p bbq_g2n bbq_t2 VSS nfet_03v3 ad=2p pd=5u as=2p ps=5u w=4u l=1u
X57 b_n2 b_n2 b_vh VDD pfet_03v3 ad=2p pd=5u as=2p ps=5u w=4u l=1u
X58 VDD bbq_o1n VSS ppolyf_u r_width=2u r_length=57.14u
X59 ri_p lna_outn lna_x2i_tail VSS nfet_03v3 ad=5p pd=11u as=5p ps=11u w=10u l=0.28u
X60 bbq_mRp3a bbq_mRp3a bbq_vb bbq_vb pfet_03v3 ad=0.42p pd=2.84u as=0.42p ps=2.84u w=0.42u l=1u
X61 lo_lq_D1qb lo_lq_D1y lo_lq_vq lo_lq_vq pfet_03v3 ad=2p pd=6u as=0.9p ps=4.9u w=2u l=0.28u
X62 lo_lq_D1qb lsq a_47706_713# VSS nfet_03v3 ad=1p pd=4u as=0.28p ps=1.56u w=1u l=0.28u
X63 VDD lo_bi_Ny0 lo_bi_Ny1 VDD pfet_03v3 ad=2p pd=6u as=2p ps=6u w=2u l=0.28u
X64 q_i li_cq VDD VDD pfet_03v3 ad=5p pd=12u as=2.25p ps=10.9u w=5u l=0.28u
X65 bbi_t1 bi_n bbi_o1p VSS nfet_03v3 ad=10p pd=21u as=10p ps=21u w=20u l=1u
X66 lq_cq lq_co VDD VDD pfet_03v3 ad=1.25p pd=4.5u as=0.5625p ps=3.4u w=1.25u l=0.28u
X67 bbq_mRp3b bbq_mRp3b bbq_vb bbq_vb pfet_03v3 ad=0.42p pd=2.84u as=0.42p ps=2.84u w=0.42u l=1u
X68 enb en VDD VDD pfet_03v3 ad=1p pd=4u as=0.45p ps=2.9u w=1u l=0.28u
X69 VDD lo_bq_Ny0 lo_bq_Ny1 VDD pfet_03v3 ad=2p pd=6u as=2p ps=6u w=2u l=0.28u
X70 lo_bi_b lo_bi_a VDD VDD pfet_03v3 ad=1.05p pd=4.1u as=1.05p ps=4.1u w=1.05u l=0.28u
X71 bbi_g2n bbi_vgr bbi_vb bbi_vb pfet_03v3 ad=0.42p pd=2.84u as=0.42p ps=2.84u w=0.42u l=12u
X72 VDD lo_bi_b lo_bi_Ny0 VDD pfet_03v3 ad=1.25p pd=4.5u as=0.625p ps=2.25u w=1.25u l=0.28u
X73 bbq_o1n bq_p bbq_t1 VSS nfet_03v3 ad=20p pd=42u as=10p ps=21u w=20u l=1u
X74 li_mRpCa li_mRpCa li_gcp li_gcp pfet_03v3 ad=0.42p pd=2.84u as=0.42p ps=2.84u w=0.42u l=1u
X75 VDD oq_n VSS ppolyf_u_1k r_width=1u r_length=0.2m
X76 bbi_t1 bi_n bbi_o1p VSS nfet_03v3 ad=10p pd=21u as=10p ps=21u w=20u l=1u
X77 bbq_o1n bq_p bbq_t1 VSS nfet_03v3 ad=10p pd=21u as=10p ps=21u w=20u l=1u
X78 VSS nb lna_tail VSS nfet_03v3 ad=2.8p pd=10.56u as=5p ps=11u w=10u l=0.5u
X79 lo_bq_Pgs lo_bq_a lo_bq_Py0 VSS nfet_03v3 ad=0.28p pd=1.56u as=1p ps=4u w=1u l=0.28u
X80 b_nr nb b_n2 VSS nfet_03v3 ad=1p pd=3u as=2p ps=6u w=2u l=0.5u
X81 li_mRpCb li_mRpCb li_gcn li_gcn pfet_03v3 ad=0.42p pd=2.84u as=0.42p ps=2.84u w=0.42u l=1u
X82 lo_bq_b VDD lo_bq_tb VSS nfet_03v3 ad=1p pd=4u as=1p ps=4u w=1u l=0.28u
X83 lo_bq_b lo_bq_a VDD VDD pfet_03v3 ad=1.05p pd=4.1u as=1.05p ps=4.1u w=1.05u l=0.28u
X84 bbq_g3n bbq_vgr bbq_vb bbq_vb pfet_03v3 ad=0.42p pd=2.84u as=0.42p ps=2.84u w=0.42u l=12u
X85 bbq_o2n bbq_g3n bbq_o2n bbq_o2n pfet_03v3 ad=12.285p pd=26.57u as=36.855p ps=79.71u w=12.285u l=10u
X86 VDD lo_bq_b lo_bq_Ny0 VDD pfet_03v3 ad=1.25p pd=4.5u as=0.625p ps=2.25u w=1.25u l=0.28u
X87 lq_lp lq_gln lq_tL VSS nfet_03v3 ad=2p pd=5u as=2p ps=5u w=4u l=0.5u
X88 a_48024_1776# lo_lq_D1qb lo_lq_vq lo_lq_vq pfet_03v3 ad=0.56p pd=2.56u as=0.56p ps=2.56u w=2u l=0.28u
X89 lq_ct lq_gcn lq_cb VSS nfet_03v3 ad=1p pd=3u as=1p ps=3u w=2u l=0.5u
X90 VSS li_vb VSS ppolyf_u_1k r_width=1u r_length=0.10002m
X91 lna_tail nb VSS VSS nfet_03v3 ad=5p pd=11u as=2.8p ps=10.56u w=10u l=0.5u
X92 li_cb li_ca VDD VDD pfet_03v3 ad=1.7p pd=5.4u as=0.765p ps=4.3u w=1.7u l=0.5u
X93 rq_p lob_q bq_n VSS nfet_03v3 ad=8p pd=18u as=4p ps=9u w=8u l=0.28u
X94 lna_outn inp lna_tail VSS nfet_03v3 ad=5p pd=11u as=5p ps=11u w=10u l=0.28u
X95 lna_x2i_tail nb VSS VSS nfet_03v3 ad=5p pd=11u as=2.8p ps=10.56u w=10u l=0.5u
X96 bbi_o1p bi_n bbi_t1 VSS nfet_03v3 ad=10p pd=21u as=10p ps=21u w=20u l=1u
X97 VSS nb lna_tail VSS nfet_03v3 ad=2.8p pd=10.56u as=5p ps=11u w=10u l=0.5u
X98 lna_outp inn lna_tail VSS nfet_03v3 ad=5p pd=11u as=5p ps=11u w=10u l=0.28u
X99 bbq_o2p bbq_g3p bbq_o2p bbq_o2p pfet_03v3 ad=6.1425p pd=13.285u as=36.855p ps=79.71u w=12.285u l=10u
X100 bbi_o2p bbi_g2n bbi_t2 VSS nfet_03v3 ad=2p pd=5u as=2p ps=5u w=4u l=1u
X101 ri_n lob_i bi_p VSS nfet_03v3 ad=4p pd=9u as=4p ps=9u w=8u l=0.28u
X102 VSS bq_p VSS VSS nfet_03v3 ad=2.2932p pd=8.75u as=0 ps=0 w=8.19u l=5u
X103 lna_vcm inn VSS ppolyf_u_1k r_width=1u r_length=20u
X104 bbq_t1 bq_n bbq_o1p VSS nfet_03v3 ad=10p pd=21u as=10p ps=21u w=20u l=1u
X105 bbi_o1p bbi_g2p bbi_o1p bbi_o1p pfet_03v3 ad=12.285p pd=26.57u as=36.855p ps=79.71u w=12.285u l=10u
X106 lna_tail nb VSS VSS nfet_03v3 ad=5p pd=11u as=2.8p ps=10.56u w=10u l=0.5u
X107 lq_lp lq_gcp lq_lp lq_lp pfet_03v3 ad=12.285p pd=26.57u as=24.57p ps=53.14u w=12.285u l=10u
X108 VSS nb lna_x2i_tail VSS nfet_03v3 ad=2.8p pd=10.56u as=5p ps=11u w=10u l=0.5u
X109 lo_bi_Py0 lo_bi_a VDD VDD pfet_03v3 ad=0.625p pd=2.25u as=1.25p ps=4.5u w=1.25u l=0.28u
X110 lq_vb lq_vbt VSS ppolyf_u_1k r_width=1u r_length=0.15m
X111 bbq_t2 nb VSS VSS nfet_03v3 ad=0.3304p pd=2.76u as=0.1774p ps=1.74u w=0.3u l=0.5u
X112 lo_bi_b VSS lo_bi_tb VDD pfet_03v3 ad=2.5p pd=7u as=2.5p ps=7u w=2.5u l=0.28u
X113 VSS bbq_o2n VSS VSS nfet_03v3 ad=12.285p pd=25.57u as=0 ps=0 w=24.57u l=10u
X114 lq_mRpCa lq_mRpCa lq_vb lq_vb pfet_03v3 ad=0.42p pd=2.84u as=0.42p ps=2.84u w=0.42u l=1u
X115 lna_tail inp lna_outn VSS nfet_03v3 ad=5p pd=11u as=5p ps=11u w=10u l=0.28u
X116 lna_outn inp lna_tail VSS nfet_03v3 ad=5p pd=11u as=5p ps=11u w=10u l=0.28u
X117 li_lp li_gln li_tL VSS nfet_03v3 ad=2p pd=5u as=2p ps=5u w=4u l=0.5u
X118 lo_bq_Py0 lo_bq_a VDD VDD pfet_03v3 ad=0.625p pd=2.25u as=1.25p ps=4.5u w=1.25u l=0.28u
X119 ri_n lna_outp lna_x2i_tail VSS nfet_03v3 ad=10p pd=22u as=5p ps=11u w=10u l=0.28u
X120 lo_bq_b VSS lo_bq_tb VDD pfet_03v3 ad=2.5p pd=7u as=2.5p ps=7u w=2.5u l=0.28u
X121 lna_x2i_tail nb VSS VSS nfet_03v3 ad=5p pd=11u as=2.8p ps=10.56u w=10u l=0.5u
X122 lq_cx lq_cx VSS VSS nfet_03v3 ad=1p pd=4u as=0.45p ps=2.9u w=1u l=0.5u
X123 bbq_o1n bbq_g2n bbq_o1n bbq_o1n pfet_03v3 ad=12.285p pd=26.57u as=36.855p ps=79.71u w=12.285u l=10u
X124 bbq_o1n bq_p bbq_t1 VSS nfet_03v3 ad=10p pd=21u as=10p ps=21u w=20u l=1u
X125 li_co li_ca VDD VDD pfet_03v3 ad=2p pd=6u as=0.9p ps=4.9u w=2u l=0.5u
X126 VSS nb lna_tail VSS nfet_03v3 ad=2.8p pd=10.56u as=5p ps=11u w=10u l=0.5u
X127 rq_n VDD VSS ppolyf_u r_width=2u r_length=9.14u
X128 bbi_g2p bbi_vgr bbi_vb bbi_vb pfet_03v3 ad=0.42p pd=2.84u as=0.42p ps=2.84u w=0.42u l=12u
X129 lna_tail inn lna_outp VSS nfet_03v3 ad=5p pd=11u as=5p ps=11u w=10u l=0.28u
X130 VSS oq_p VSS VSS nfet_03v3 ad=12.285p pd=25.57u as=0 ps=0 w=24.57u l=10u
X131 bbi_g3n bbi_vgr bbi_vb bbi_vb pfet_03v3 ad=0.42p pd=2.84u as=0.42p ps=2.84u w=0.42u l=12u
X132 VSS lo_bq_Py2 lo_q VSS nfet_03v3 ad=2.5p pd=7u as=1.25p ps=3.5u w=2.5u l=0.28u
X133 lo_bi_a lo_bi_ta VSS VSS nfet_03v3 ad=1p pd=4u as=1p ps=4u w=1u l=0.28u
X134 rq_n lna_outp lna_x2q_tail VSS nfet_03v3 ad=10p pd=22u as=5p ps=11u w=10u l=0.28u
X135 lq_gcn lq_vgr lq_vb lq_vb pfet_03v3 ad=0.42p pd=2.84u as=0.42p ps=2.84u w=0.42u l=12u
X136 bbi_t3 bbi_g3n oi_p VSS nfet_03v3 ad=2p pd=5u as=2p ps=5u w=4u l=1u
X137 lna_tail inp lna_outn VSS nfet_03v3 ad=5p pd=11u as=5p ps=11u w=10u l=0.28u
X138 VSS VDD VSS VSS nfet_03v3 ad=3.36p pd=12.56u as=0 ps=0 w=12u l=10u
X139 bbq_o1p bq_n bbq_t1 VSS nfet_03v3 ad=10p pd=21u as=10p ps=21u w=20u l=1u
X140 lo_bi_t lo_bi_x VSS VSS nfet_03v3 ad=0.42p pd=2.84u as=0.42p ps=2.84u w=0.42u l=0.28u
X141 bbq_mRp2a bbq_mRp2a bbq_g2p bbq_g2p pfet_03v3 ad=0.42p pd=2.84u as=0.42p ps=2.84u w=0.42u l=1u
X142 VSS nb lna_tail VSS nfet_03v3 ad=2.8p pd=10.56u as=5p ps=11u w=10u l=0.5u
X143 lo_lq_vq lsq lo_lq_D1y lo_lq_vq pfet_03v3 ad=0.56p pd=2.56u as=2p ps=6u w=2u l=0.28u
X144 lo_lq_D1x lo_lq_D1qb VSS VSS nfet_03v3 ad=1p pd=4u as=0.28p ps=1.56u w=1u l=0.28u
X145 li_mRpLb li_mRpLb li_gln li_gln pfet_03v3 ad=0.42p pd=2.84u as=0.42p ps=2.84u w=0.42u l=1u
X146 ri_n lo_i bi_p VDD pfet_03v3 ad=8p pd=17u as=8p ps=17u w=16u l=0.28u
X147 bbi_o2n bbi_g3n bbi_o2n bbi_o2n pfet_03v3 ad=6.1425p pd=13.285u as=36.855p ps=79.71u w=12.285u l=10u
X148 lo_bi_g0s ls lo_bi_x VSS nfet_03v3 ad=0.14p pd=1.06u as=0.5p ps=3u w=0.5u l=0.28u
X149 lo_bi_Ny0 en VDD VDD pfet_03v3 ad=0.625p pd=2.25u as=1.25p ps=4.5u w=1.25u l=0.28u
X150 VSS oi_n VSS VSS nfet_03v3 ad=12.285p pd=25.57u as=0 ps=0 w=24.57u l=10u
X151 VSS VDD VSS VSS nfet_03v3 ad=3.36p pd=12.56u as=0 ps=0 w=12u l=10u
X152 lna_tail inn lna_outp VSS nfet_03v3 ad=5p pd=11u as=5p ps=11u w=10u l=0.28u
X153 lna_vcm inp VSS ppolyf_u_1k r_width=1u r_length=20u
X154 bbq_t1 bq_n bbq_o1p VSS nfet_03v3 ad=10p pd=21u as=10p ps=21u w=20u l=1u
X155 bbq_vgr bbq_vgr bbq_vb bbq_vb pfet_03v3 ad=4p pd=10u as=4p ps=10u w=4u l=1u
X156 lo_bq_Ny0 en VDD VDD pfet_03v3 ad=0.625p pd=2.25u as=1.25p ps=4.5u w=1.25u l=0.28u
X157 lo_lq_tt lsq VSS VSS nfet_03v3 ad=0.42p pd=2.84u as=0.189p ps=1.74u w=0.42u l=0.28u
X158 bbq_vb bbq_vbt VSS ppolyf_u_1k r_width=1u r_length=0.15002m
X159 bbi_o1n bi_p bbi_t1 VSS nfet_03v3 ad=10p pd=21u as=10p ps=21u w=20u l=1u
X160 lna_tail inp lna_outn VSS nfet_03v3 ad=5p pd=11u as=5p ps=11u w=10u l=0.28u
X161 nb b_n2 b_vh VDD pfet_03v3 ad=4p pd=10u as=2p ps=5u w=4u l=1u
X162 VSS bbi_o2n VSS VSS nfet_03v3 ad=12.285p pd=25.57u as=0 ps=0 w=24.57u l=10u
X163 b_x nb VSS VSS nfet_03v3 ad=2p pd=6u as=2p ps=6u w=2u l=0.28u
X164 a_47706_713# lo_lq_D1y VSS VSS nfet_03v3 ad=0.28p pd=1.56u as=0.45p ps=2.9u w=1u l=0.28u
X165 VSS VDD VSS VSS nfet_03v3 ad=3.36p pd=12.56u as=0 ps=0 w=12u l=10u
X166 li_gcp li_vgr li_vb li_vb pfet_03v3 ad=0.42p pd=2.84u as=0.42p ps=2.84u w=0.42u l=12u
X167 bi_p lo_i ri_p VSS nfet_03v3 ad=4p pd=9u as=8p ps=18u w=8u l=0.28u
X168 lo_bq_a lo_bq_ta VSS VSS nfet_03v3 ad=1p pd=4u as=1p ps=4u w=1u l=0.28u
X169 VSS nb VSS VSS nfet_03v3 ad=4.095p pd=9.19u as=0 ps=0 w=8.19u l=10u
X170 lna_tail inn lna_outp VSS nfet_03v3 ad=5p pd=11u as=5p ps=11u w=10u l=0.28u
X171 VSS oi_p VSS VSS nfet_03v3 ad=12.285p pd=25.57u as=0 ps=0 w=24.57u l=10u
X172 b_n2 nb b_nr VSS nfet_03v3 ad=2p pd=6u as=1p ps=3u w=2u l=0.5u
X173 lq_ca lq_ca VDD VDD pfet_03v3 ad=1p pd=4u as=0.45p ps=2.9u w=1u l=0.5u
X174 lna_outp inn lna_tail VSS nfet_03v3 ad=5p pd=11u as=5p ps=11u w=10u l=0.28u
X175 VSS oq_n VSS VSS nfet_03v3 ad=24.57p pd=51.14u as=0 ps=0 w=24.57u l=10u
X176 lna_vcm VSS VSS ppolyf_u_1k r_width=1u r_length=30u
X177 lna_outp inn lna_tail VSS nfet_03v3 ad=5p pd=11u as=5p ps=11u w=10u l=0.28u
X178 VSS bbi_vb VSS VSS nfet_03v3 ad=24.57p pd=51.14u as=0 ps=0 w=24.57u l=10u
X179 bbq_o1p bq_n bbq_t1 VSS nfet_03v3 ad=10p pd=21u as=10p ps=21u w=20u l=1u
X180 VDD VSS lo_lq_vq VDD pfet_03v3 ad=4.5p pd=20.9u as=5p ps=11u w=10u l=0.28u
X181 bbi_t1 bi_n bbi_o1p VSS nfet_03v3 ad=10p pd=21u as=10p ps=21u w=20u l=1u
X182 lsq VSS VSS VSS nfet_03v3 ad=0.42p pd=2.84u as=0.189p ps=1.74u w=0.42u l=0.28u
X183 lna_x2i_tail lna_outn ri_p VSS nfet_03v3 ad=5p pd=11u as=5p ps=11u w=10u l=0.28u
X184 VSS lo_lq_vq VSS VSS nfet_03v3 ad=2.2932p pd=8.75u as=0 ps=0 w=8.19u l=10u
X185 lo_bq_g0s lsq lo_bq_x VSS nfet_03v3 ad=0.14p pd=1.06u as=0.5p ps=3u w=0.5u l=0.28u
X186 q_i li_cq VSS VSS nfet_03v3 ad=2p pd=6u as=0.9p ps=4.9u w=2u l=0.28u
X187 lna_outn inp lna_tail VSS nfet_03v3 ad=5p pd=11u as=5p ps=11u w=10u l=0.28u
X188 lo_bi_Ngs en VSS VSS nfet_03v3 ad=0.28p pd=1.56u as=1p ps=4u w=1u l=0.28u
X189 lna_x2q_tail lna_outp rq_n VSS nfet_03v3 ad=5p pd=11u as=10p ps=22u w=10u l=0.28u
X190 lna_tail inp lna_outn VSS nfet_03v3 ad=5p pd=11u as=5p ps=11u w=10u l=0.28u
X191 VSS bq_p VSS VSS nfet_03v3 ad=3.6855p pd=17.28u as=0 ps=0 w=8.19u l=5u
X192 lo_bi_a lo_bi_ta VDD VDD pfet_03v3 ad=2.5p pd=7u as=2.5p ps=7u w=2.5u l=0.28u
X193 bbi_o2n bbi_g2p bbi_t2 VSS nfet_03v3 ad=4p pd=10u as=2p ps=5u w=4u l=1u
X194 bbq_t3 bbq_g3n oq_p VSS nfet_03v3 ad=2p pd=5u as=2p ps=5u w=4u l=1u
X195 bbi_vbt enb VDD VDD pfet_03v3 ad=1p pd=4u as=0.45p ps=2.9u w=1u l=0.28u
X196 bbq_vgr nb VSS VSS nfet_03v3 ad=0.42p pd=2.84u as=0.42p ps=2.84u w=0.42u l=50u
X197 VDD oi_p VSS ppolyf_u_1k r_width=1u r_length=0.2m
X198 lo_bq_a lo_bq_ta VDD VDD pfet_03v3 ad=2.5p pd=7u as=2.5p ps=7u w=2.5u l=0.28u
X199 li_ct li_gcp li_ca VSS nfet_03v3 ad=1p pd=3u as=2p ps=6u w=2u l=0.5u
X200 VSS bbq_o2p VSS VSS nfet_03v3 ad=12.285p pd=25.57u as=0 ps=0 w=24.57u l=10u
X201 bbq_t1 nb VSS VSS nfet_03v3 ad=4p pd=9u as=3.6p ps=16.9u w=8u l=0.5u
X202 bbq_t1 bq_p bbq_o1n VSS nfet_03v3 ad=10p pd=21u as=10p ps=21u w=20u l=1u
X203 bbq_t1 bq_p bbq_o1n VSS nfet_03v3 ad=10p pd=21u as=20p ps=42u w=20u l=1u
X204 VSS lq_vb VSS ppolyf_u_1k r_width=1u r_length=0.10002m
X205 bbi_o1p bi_n bbi_t1 VSS nfet_03v3 ad=10p pd=21u as=10p ps=21u w=20u l=1u
X206 li_cb li_cb VDD VDD pfet_03v3 ad=1p pd=4u as=0.45p ps=2.9u w=1u l=0.5u
X207 bbi_mRp2a bbi_mRp2a bbi_g2p bbi_g2p pfet_03v3 ad=0.42p pd=2.84u as=0.42p ps=2.84u w=0.42u l=1u
X208 bbi_mRp2a bbi_mRp2a bbi_vb bbi_vb pfet_03v3 ad=0.42p pd=2.84u as=0.42p ps=2.84u w=0.42u l=1u
X209 bq_p lo_q rq_p VSS nfet_03v3 ad=4p pd=9u as=8p ps=18u w=8u l=0.28u
X210 VSS nb bbi_t1 VSS nfet_03v3 ad=3.6p pd=16.9u as=4p ps=9u w=8u l=0.5u
X211 bbq_o1p bq_n bbq_t1 VSS nfet_03v3 ad=10p pd=21u as=10p ps=21u w=20u l=1u
X212 VSS lo_bq_Ny1 lo_bq_Ny2 VSS nfet_03v3 ad=2p pd=6u as=2p ps=6u w=2u l=0.28u
X213 VSS li_vb VSS VSS nfet_03v3 ad=5.52825p pd=25.47u as=0 ps=0 w=12.285u l=10u
X214 lq_vgr lq_vgr lq_vb lq_vb pfet_03v3 ad=4p pd=10u as=4p ps=10u w=4u l=1u
X215 bbq_o2n bbq_g2p bbq_t2 VSS nfet_03v3 ad=4p pd=10u as=2p ps=5u w=4u l=1u
X216 VDD bbi_o1n VSS ppolyf_u r_width=2u r_length=57.14u
X217 lo_bi_a lo_bi_b VDD VDD pfet_03v3 ad=1.05p pd=4.1u as=1.05p ps=4.1u w=1.05u l=0.28u
X218 VDD bbq_o2p VSS ppolyf_u_1k r_width=1u r_length=0.2m
X219 lo_bq_Ngs en VSS VSS nfet_03v3 ad=0.28p pd=1.56u as=1p ps=4u w=1u l=0.28u
X220 bbq_o1n bq_p bbq_t1 VSS nfet_03v3 ad=10p pd=21u as=10p ps=21u w=20u l=1u
X221 rq_p lo_q bq_n VDD pfet_03v3 ad=16p pd=34u as=8p ps=17u w=16u l=0.28u
X222 lo_q lo_bq_Py2 VSS VSS nfet_03v3 ad=1.25p pd=3.5u as=2.5p ps=7u w=2.5u l=0.28u
X223 VSS en lo_bi_g0s VSS nfet_03v3 ad=0.5p pd=3u as=0.14p ps=1.06u w=0.5u l=0.28u
X224 lq_cq lq_co VSS VSS nfet_03v3 ad=0.5p pd=3u as=0.225p ps=1.9u w=0.5u l=0.28u
X225 lna_tail inp lna_outn VSS nfet_03v3 ad=5p pd=11u as=5p ps=11u w=10u l=0.28u
X226 lo_bq_a lo_bq_b VDD VDD pfet_03v3 ad=1.05p pd=4.1u as=1.05p ps=4.1u w=1.05u l=0.28u
X227 VSS li_vb VSS VSS nfet_03v3 ad=3.4398p pd=12.845u as=0 ps=0 w=12.285u l=10u
X228 bbi_t1 bi_p bbi_o1n VSS nfet_03v3 ad=10p pd=21u as=10p ps=21u w=20u l=1u
X229 bbq_o2p bbq_g3p bbq_o2p bbq_o2p pfet_03v3 ad=12.285p pd=26.57u as=0 ps=0 w=12.285u l=10u
X230 bbi_t2 nb VSS VSS nfet_03v3 ad=0.3304p pd=2.76u as=0.1774p ps=1.74u w=0.3u l=0.5u
X231 lna_outp inn lna_tail VSS nfet_03v3 ad=5p pd=11u as=5p ps=11u w=10u l=0.28u
X232 lq_co lq_cx VSS VSS nfet_03v3 ad=1p pd=4u as=0.45p ps=2.9u w=1u l=0.5u
X233 VSS bbi_o2p VSS VSS nfet_03v3 ad=24.57p pd=51.14u as=0 ps=0 w=24.57u l=10u
X234 bbq_o1p bbq_g2p bbq_o1p bbq_o1p pfet_03v3 ad=6.1425p pd=13.285u as=36.855p ps=79.71u w=12.285u l=10u
X235 lo_bq_Py2 lo_bq_Py1 VSS VSS nfet_03v3 ad=2p pd=6u as=2p ps=6u w=2u l=0.28u
X236 li_mRpCb li_mRpCb li_vb li_vb pfet_03v3 ad=0.42p pd=2.84u as=0.42p ps=2.84u w=0.42u l=1u
X237 li_ca li_gcp li_ct VSS nfet_03v3 ad=2p pd=6u as=1p ps=3u w=2u l=0.5u
X238 bbq_o1n bbq_g2n bbq_o1n bbq_o1n pfet_03v3 ad=6.1425p pd=13.285u as=0 ps=0 w=12.285u l=10u
X239 oi_n li_gln oi_n oi_n pfet_03v3 ad=12.285p pd=26.57u as=24.57p ps=53.14u w=12.285u l=10u
X240 bbi_t1 bi_p bbi_o1n VSS nfet_03v3 ad=10p pd=21u as=10p ps=21u w=20u l=1u
X241 bbq_t1 bq_p bbq_o1n VSS nfet_03v3 ad=10p pd=21u as=10p ps=21u w=20u l=1u
X242 lo_lq_D1x lsq a_48024_1776# lo_lq_vq pfet_03v3 ad=2p pd=6u as=0.56p ps=2.56u w=2u l=0.28u
X243 lna_tail inn lna_outp VSS nfet_03v3 ad=5p pd=11u as=5p ps=11u w=10u l=0.28u
X244 b_x VSS b_vh VDD pfet_03v3 ad=0.42p pd=2.84u as=0.42p ps=2.84u w=0.42u l=10u
X245 VSS bbq_o2n VSS VSS nfet_03v3 ad=12.285p pd=25.57u as=0 ps=0 w=24.57u l=10u
X246 lna_x2i_tail lna_outp ri_n VSS nfet_03v3 ad=5p pd=11u as=5p ps=11u w=10u l=0.28u
X247 lq_tL lq_glp lq_ln VSS nfet_03v3 ad=2p pd=5u as=4p ps=10u w=4u l=0.5u
X248 VSS lsq a_48450_713# VSS nfet_03v3 ad=0.28p pd=1.56u as=0.28p ps=1.56u w=1u l=0.28u
X249 lq_cb lq_gcn lq_ct VSS nfet_03v3 ad=1p pd=3u as=1p ps=3u w=2u l=0.5u
X250 VSS nb lna_tail VSS nfet_03v3 ad=2.8p pd=10.56u as=5p ps=11u w=10u l=0.5u
X251 lo_i lo_bi_Py2 VDD VDD pfet_03v3 ad=4.165p pd=10.33u as=2.0825p ps=5.165u w=4.165u l=0.28u
X252 lq_mRpLb lq_mRpLb lq_gln lq_gln pfet_03v3 ad=0.42p pd=2.84u as=0.42p ps=2.84u w=0.42u l=1u
X253 bi_p lob_i ri_p VDD pfet_03v3 ad=8p pd=17u as=16p ps=34u w=16u l=0.28u
X254 VSS lo_bi_Ny1 lo_bi_Ny2 VSS nfet_03v3 ad=2p pd=6u as=2p ps=6u w=2u l=0.28u
X255 rq_p lna_outn lna_x2q_tail VSS nfet_03v3 ad=5p pd=11u as=5p ps=11u w=10u l=0.28u
X256 bbi_mRp3a bbi_mRp3a bbi_vb bbi_vb pfet_03v3 ad=0.42p pd=2.84u as=0.42p ps=2.84u w=0.42u l=1u
X257 bbi_o1n bi_p bbi_t1 VSS nfet_03v3 ad=10p pd=21u as=10p ps=21u w=20u l=1u
X258 VSS lo_bi_Py2 lo_i VSS nfet_03v3 ad=2.5p pd=7u as=1.25p ps=3.5u w=2.5u l=0.28u
X259 lo_q lo_bq_Py2 VDD VDD pfet_03v3 ad=4.165p pd=10.33u as=2.0825p ps=5.165u w=4.165u l=0.28u
X260 VSS oq_p VSS VSS nfet_03v3 ad=12.285p pd=25.57u as=0 ps=0 w=24.57u l=10u
X261 VSS en lo_bq_g0s VSS nfet_03v3 ad=0.5p pd=3u as=0.14p ps=1.06u w=0.5u l=0.28u
X262 lna_tail nb VSS VSS nfet_03v3 ad=5p pd=11u as=2.8p ps=10.56u w=10u l=0.5u
X263 VSS nb lna_tail VSS nfet_03v3 ad=2.8p pd=10.56u as=5p ps=11u w=10u l=0.5u
X264 lna_x2q_tail lna_outp rq_n VSS nfet_03v3 ad=5p pd=11u as=5p ps=11u w=10u l=0.28u
X265 lna_outp inn lna_tail VSS nfet_03v3 ad=5p pd=11u as=5p ps=11u w=10u l=0.28u
X266 lna_x2i_tail nb VSS VSS nfet_03v3 ad=5p pd=11u as=4.5p ps=20.9u w=10u l=0.5u
X267 bbq_o1n bq_p bbq_t1 VSS nfet_03v3 ad=10p pd=21u as=10p ps=21u w=20u l=1u
X268 lq_mRpLb lq_mRpLb lq_vb lq_vb pfet_03v3 ad=0.42p pd=2.84u as=0.42p ps=2.84u w=0.42u l=1u
X269 lna_tail nb VSS VSS nfet_03v3 ad=5p pd=11u as=2.8p ps=10.56u w=10u l=0.5u
X270 lo_bi_Ny0 lo_bi_b lo_bi_Ngs VSS nfet_03v3 ad=1p pd=4u as=0.28p ps=1.56u w=1u l=0.28u
X271 bbi_t1 bi_p bbi_o1n VSS nfet_03v3 ad=10p pd=21u as=10p ps=21u w=20u l=1u
X272 lna_x2q_tail nb VSS VSS nfet_03v3 ad=5p pd=11u as=10p ps=22u w=10u l=0.5u
X273 bbq_mRp2a bbq_mRp2a bbq_vb bbq_vb pfet_03v3 ad=0.42p pd=2.84u as=0.42p ps=2.84u w=0.42u l=1u
X274 VSS bi_p VSS VSS nfet_03v3 ad=3.6855p pd=17.28u as=0 ps=0 w=8.19u l=5u
X275 li_tL li_glp li_ln VSS nfet_03v3 ad=2p pd=5u as=4p ps=10u w=4u l=0.5u
X276 bbi_o2n bbi_g3n bbi_o2n bbi_o2n pfet_03v3 ad=12.285p pd=26.57u as=0 ps=0 w=12.285u l=10u
X277 lna_tail nb VSS VSS nfet_03v3 ad=5p pd=11u as=2.8p ps=10.56u w=10u l=0.5u
X278 lo_bi_Py1 lo_bi_Py0 VSS VSS nfet_03v3 ad=0.8p pd=3.6u as=0.8p ps=3.6u w=0.8u l=0.28u
X279 VDD bbq_o1p VSS ppolyf_u r_width=2u r_length=57.14u
X280 VSS oi_n VSS VSS nfet_03v3 ad=12.285p pd=25.57u as=0 ps=0 w=24.57u l=10u
X281 lq_ca lq_cb VDD VDD pfet_03v3 ad=1.7p pd=5.4u as=0.765p ps=4.3u w=1.7u l=0.5u
X282 rq_p lna_outn lna_x2q_tail VSS nfet_03v3 ad=5p pd=11u as=5p ps=11u w=10u l=0.28u
X283 VSS nb lna_x2i_tail VSS nfet_03v3 ad=2.8p pd=10.56u as=5p ps=11u w=10u l=0.5u
X284 lna_outn inp lna_tail VSS nfet_03v3 ad=5p pd=11u as=5p ps=11u w=10u l=0.28u
X285 lq_vbt enb VDD VDD pfet_03v3 ad=1p pd=4u as=0.45p ps=2.9u w=1u l=0.28u
X286 lna_tail nb VSS VSS nfet_03v3 ad=5p pd=11u as=2.8p ps=10.56u w=10u l=0.5u
X287 lna_tail inp lna_outn VSS nfet_03v3 ad=5p pd=11u as=5p ps=11u w=10u l=0.28u
X288 q_q lq_cq VDD VDD pfet_03v3 ad=5p pd=12u as=2.25p ps=10.9u w=5u l=0.28u
X289 bbi_o2p bbi_g3p bbi_o2p bbi_o2p pfet_03v3 ad=6.1425p pd=13.285u as=36.855p ps=79.71u w=12.285u l=10u
X290 VSS bbi_o2n VSS VSS nfet_03v3 ad=12.285p pd=25.57u as=0 ps=0 w=24.57u l=10u
X291 VSS lna_vcm VSS VSS nfet_03v3 ad=4.915p pd=10.83u as=0 ps=0 w=9.83u l=10u
X292 lna_x2q_tail lna_outp rq_n VSS nfet_03v3 ad=5p pd=11u as=5p ps=11u w=10u l=0.28u
X293 ri_p lna_outn lna_x2i_tail VSS nfet_03v3 ad=5p pd=11u as=5p ps=11u w=10u l=0.28u
X294 VDD bbq_o2n VSS ppolyf_u_1k r_width=1u r_length=0.2m
X295 bbq_t1 bq_n bbq_o1p VSS nfet_03v3 ad=10p pd=21u as=10p ps=21u w=20u l=1u
X296 bbq_t1 bq_n bbq_o1p VSS nfet_03v3 ad=10p pd=21u as=10p ps=21u w=20u l=1u
X297 VSS oi_n VSS VSS nfet_03v3 ad=24.57p pd=51.14u as=0 ps=0 w=24.57u l=10u
X298 lo_bi_b lo_bi_a VSS VSS nfet_03v3 ad=0.42p pd=2.84u as=0.42p ps=2.84u w=0.42u l=0.28u
X299 VSS nb VSS VSS nfet_03v3 ad=8.19p pd=18.38u as=0 ps=0 w=8.19u l=10u
X300 lq_mRpCb lq_mRpCb lq_gcn lq_gcn pfet_03v3 ad=0.42p pd=2.84u as=0.42p ps=2.84u w=0.42u l=1u
X301 bbi_o1n bi_p bbi_t1 VSS nfet_03v3 ad=10p pd=21u as=10p ps=21u w=20u l=1u
X302 lob_q lo_bq_Ny2 VSS VSS nfet_03v3 ad=1.25p pd=3.5u as=2.5p ps=7u w=2.5u l=0.28u
X303 VSS bi_p VSS VSS nfet_03v3 ad=2.2932p pd=8.75u as=0 ps=0 w=8.19u l=5u
X304 li_cq li_co VDD VDD pfet_03v3 ad=1.25p pd=4.5u as=0.5625p ps=3.4u w=1.25u l=0.28u
X305 lna_tail inn lna_outp VSS nfet_03v3 ad=5p pd=11u as=5p ps=11u w=10u l=0.28u
X306 lna_outp inn lna_tail VSS nfet_03v3 ad=5p pd=11u as=5p ps=11u w=10u l=0.28u
X307 li_gln li_vgr li_vb li_vb pfet_03v3 ad=0.42p pd=2.84u as=0.42p ps=2.84u w=0.42u l=12u
X308 VSS nb lna_x2q_tail VSS nfet_03v3 ad=5p pd=11u as=5p ps=11u w=10u l=0.5u
X309 ri_n lna_outp lna_x2i_tail VSS nfet_03v3 ad=5p pd=11u as=5p ps=11u w=10u l=0.28u
X310 VSS nb lna_tail VSS nfet_03v3 ad=2.8p pd=10.56u as=5p ps=11u w=10u l=0.5u
X311 lo_bq_Ny0 lo_bq_b lo_bq_Ngs VSS nfet_03v3 ad=1p pd=4u as=0.28p ps=1.56u w=1u l=0.28u
X312 lo_lq_vq lo_lq_D1qb lo_lq_q1 lo_lq_vq pfet_03v3 ad=0.675p pd=3.9u as=1.5p ps=5u w=1.5u l=0.28u
X313 bbi_o1n bbi_g2n bbi_o1n bbi_o1n pfet_03v3 ad=6.1425p pd=13.285u as=36.855p ps=79.71u w=12.285u l=10u
X314 rq_p VDD VSS ppolyf_u r_width=2u r_length=9.14u
X315 lo_bq_Py1 lo_bq_Py0 VSS VSS nfet_03v3 ad=0.8p pd=3.6u as=0.8p ps=3.6u w=0.8u l=0.28u
X316 lo_bq_t lo_bq_x VSS VSS nfet_03v3 ad=0.42p pd=2.84u as=0.42p ps=2.84u w=0.42u l=0.28u
X317 bbi_t2 bbi_g2p bbi_o2n VSS nfet_03v3 ad=2p pd=5u as=4p ps=10u w=4u l=1u
X318 lna_outn inp lna_tail VSS nfet_03v3 ad=5p pd=11u as=5p ps=11u w=10u l=0.28u
X319 lq_tL nb VSS VSS nfet_03v3 ad=2p pd=6u as=0.9p ps=4.9u w=2u l=0.5u
X320 bbq_mRp3a bbq_mRp3a bbq_g3p bbq_g3p pfet_03v3 ad=0.42p pd=2.84u as=0.42p ps=2.84u w=0.42u l=1u
X321 VSS lo_bi_Ny0 lo_bi_Ny1 VSS nfet_03v3 ad=0.8p pd=3.6u as=0.8p ps=3.6u w=0.8u l=0.28u
X322 bbq_o1p bq_n bbq_t1 VSS nfet_03v3 ad=10p pd=21u as=10p ps=21u w=20u l=1u
X323 lo_bi_Py2 lo_bi_Py1 VDD VDD pfet_03v3 ad=1.25p pd=3.5u as=2.5p ps=7u w=2.5u l=0.28u
X324 bbi_t1 bi_n bbi_o1p VSS nfet_03v3 ad=10p pd=21u as=10p ps=21u w=20u l=1u
X325 VSS bi_p VSS VSS nfet_03v3 ad=2.2932p pd=8.75u as=0 ps=0 w=8.19u l=5u
X326 lob_i lo_bi_Ny2 VSS VSS nfet_03v3 ad=1.25p pd=3.5u as=2.5p ps=7u w=2.5u l=0.28u
X327 lo_lq_vq VSS VDD VDD pfet_03v3 ad=5p pd=11u as=4.5p ps=20.9u w=10u l=0.28u
X328 b_nr nb b_n2 VSS nfet_03v3 ad=1p pd=3u as=2p ps=6u w=2u l=0.5u
X329 lo_bq_Py2 lo_bq_Py1 VDD VDD pfet_03v3 ad=1.25p pd=3.5u as=2.5p ps=7u w=2.5u l=0.28u
X330 VDD lna_outp VSS ppolyf_u r_width=4u r_length=9.14u
X331 VSS bbq_o2p VSS VSS nfet_03v3 ad=12.285p pd=25.57u as=0 ps=0 w=24.57u l=10u
X332 bbq_g3p bbq_vgr bbq_vb bbq_vb pfet_03v3 ad=0.42p pd=2.84u as=0.42p ps=2.84u w=0.42u l=12u
X333 VSS nb lna_x2q_tail VSS nfet_03v3 ad=5p pd=11u as=5p ps=11u w=10u l=0.5u
X334 bbi_t1 bi_n bbi_o1p VSS nfet_03v3 ad=10p pd=21u as=10p ps=21u w=20u l=1u
X335 lna_tail inn lna_outp VSS nfet_03v3 ad=5p pd=11u as=5p ps=11u w=10u l=0.28u
X336 VSS lna_vcm VSS VSS nfet_03v3 ad=9.83p pd=21.66u as=0 ps=0 w=9.83u l=10u
X337 lna_x2q_tail nb VSS VSS nfet_03v3 ad=5p pd=11u as=5p ps=11u w=10u l=0.5u
X338 lna_outn inp lna_tail VSS nfet_03v3 ad=5p pd=11u as=5p ps=11u w=10u l=0.28u
X339 bbq_t2 bbq_g2p bbq_o2n VSS nfet_03v3 ad=2p pd=5u as=4p ps=10u w=4u l=1u
X340 b_vh b_n2 nb VDD pfet_03v3 ad=2p pd=5u as=4p ps=10u w=4u l=1u
X341 VSS bq_n VSS VSS nfet_03v3 ad=2.2932p pd=8.75u as=0 ps=0 w=8.19u l=5u
X342 bbq_g2n bbq_vgr bbq_vb bbq_vb pfet_03v3 ad=0.42p pd=2.84u as=0.42p ps=2.84u w=0.42u l=12u
X343 bq_p lob_q rq_p VDD pfet_03v3 ad=8p pd=17u as=16p ps=34u w=16u l=0.28u
X344 nb enb VSS VSS nfet_03v3 ad=0.42p pd=2.84u as=0.189p ps=1.74u w=0.42u l=0.28u
X345 oi_p bbi_g3n bbi_t3 VSS nfet_03v3 ad=2p pd=5u as=2p ps=5u w=4u l=1u
X346 lna_outp inn lna_tail VSS nfet_03v3 ad=5p pd=11u as=5p ps=11u w=10u l=0.28u
X347 lo_lq_lo2 lo_lq_lo1 lo_lq_vq lo_lq_vq pfet_03v3 ad=1.5p pd=5u as=0.675p ps=3.9u w=1.5u l=0.28u
X348 li_cx li_cx VSS VSS nfet_03v3 ad=1p pd=4u as=0.45p ps=2.9u w=1u l=0.5u
X349 bq_n lo_q rq_n VSS nfet_03v3 ad=4p pd=9u as=4p ps=9u w=8u l=0.28u
X350 bbq_t1 bq_p bbq_o1n VSS nfet_03v3 ad=10p pd=21u as=10p ps=21u w=20u l=1u
X351 lo_lq_lf lsq VSS ppolyf_u_1k r_width=1u r_length=0.15912m
X352 li_glp li_vgr li_vb li_vb pfet_03v3 ad=0.42p pd=2.84u as=0.42p ps=2.84u w=0.42u l=12u
X353 bbi_o1p bi_n bbi_t1 VSS nfet_03v3 ad=10p pd=21u as=10p ps=21u w=20u l=1u
X354 li_gcn li_vgr li_vb li_vb pfet_03v3 ad=0.42p pd=2.84u as=0.42p ps=2.84u w=0.42u l=12u
X355 lo_bi_tb lo_bi_t VDD VDD pfet_03v3 ad=3.75p pd=9.5u as=3.75p ps=9.5u w=3.75u l=0.28u
X356 lq_ln lq_glp lq_tL VSS nfet_03v3 ad=4p pd=10u as=2p ps=5u w=4u l=0.5u
X357 lo_bi_ta lo_bi_t VSS VSS nfet_03v3 ad=0.5p pd=3u as=0.5p ps=3u w=0.5u l=0.28u
X358 VSS lo_bq_Ny0 lo_bq_Ny1 VSS nfet_03v3 ad=0.8p pd=3.6u as=0.8p ps=3.6u w=0.8u l=0.28u
X359 oq_p lq_glp oq_p oq_p pfet_03v3 ad=12.285p pd=26.57u as=24.57p ps=53.14u w=12.285u l=10u
X360 lna_outn inp lna_tail VSS nfet_03v3 ad=5p pd=11u as=5p ps=11u w=10u l=0.28u
X361 VSS oq_n VSS VSS nfet_03v3 ad=12.285p pd=25.57u as=0 ps=0 w=24.57u l=10u
X362 a_48450_713# lo_lq_D1x lo_lq_D1y VSS nfet_03v3 ad=0.28p pd=1.56u as=1p ps=4u w=1u l=0.28u
X363 bbi_o1p bi_n bbi_t1 VSS nfet_03v3 ad=10p pd=21u as=10p ps=21u w=20u l=1u
X364 rq_p lna_outn lna_x2q_tail VSS nfet_03v3 ad=5p pd=11u as=5p ps=11u w=10u l=0.28u
X365 lo_bq_tb lo_bq_t VDD VDD pfet_03v3 ad=3.75p pd=9.5u as=3.75p ps=9.5u w=3.75u l=0.28u
X366 VDD lo_bi_Py2 lo_i VDD pfet_03v3 ad=2.0825p pd=5.165u as=2.0825p ps=5.165u w=4.165u l=0.28u
X367 bbi_t1 bi_n bbi_o1p VSS nfet_03v3 ad=10p pd=21u as=10p ps=21u w=20u l=1u
X368 lna_x2q_tail nb VSS VSS nfet_03v3 ad=5p pd=11u as=5p ps=11u w=10u l=0.5u
X369 VSS oi_p VSS VSS nfet_03v3 ad=12.285p pd=25.57u as=0 ps=0 w=24.57u l=10u
X370 bbq_o1p bbq_g2p bbq_o1p bbq_o1p pfet_03v3 ad=12.285p pd=26.57u as=0 ps=0 w=12.285u l=10u
X371 VDD lo_bq_Py2 lo_q VDD pfet_03v3 ad=2.0825p pd=5.165u as=2.0825p ps=5.165u w=4.165u l=0.28u
X372 lna_tail inn lna_outp VSS nfet_03v3 ad=5p pd=11u as=5p ps=11u w=10u l=0.28u
X373 lq_gcp lq_vgr lq_vb lq_vb pfet_03v3 ad=0.42p pd=2.84u as=0.42p ps=2.84u w=0.42u l=12u
X374 lq_cx lq_cb VDD VDD pfet_03v3 ad=2p pd=6u as=0.9p ps=4.9u w=2u l=0.5u
X375 lo_lq_lo2 lo_lq_lo1 VSS VSS nfet_03v3 ad=0.6p pd=3.2u as=0.27p ps=2.1u w=0.6u l=0.28u
X376 VSS bbi_o2p VSS VSS nfet_03v3 ad=12.285p pd=25.57u as=0 ps=0 w=24.57u l=10u
X377 bbq_o1n bq_p bbq_t1 VSS nfet_03v3 ad=10p pd=21u as=10p ps=21u w=20u l=1u
X378 VDD lq_ln VSS ppolyf_u r_width=1u r_length=28.56u
X379 VSS bbq_o2n VSS VSS nfet_03v3 ad=24.57p pd=51.14u as=0 ps=0 w=24.57u l=10u
X380 bbq_mRp2b bbq_mRp2b bbq_g2n bbq_g2n pfet_03v3 ad=0.42p pd=2.84u as=0.42p ps=2.84u w=0.42u l=1u
X381 li_ln li_glp li_tL VSS nfet_03v3 ad=4p pd=10u as=2p ps=5u w=4u l=0.5u
X382 lo_lq_lf VSS lo_lq_lg lo_lq_vq pfet_03v3 ad=0.2808p pd=2.76u as=0.2808p ps=2.76u w=0.22u l=2u
X383 lq_gln lq_vgr lq_vb lq_vb pfet_03v3 ad=0.42p pd=2.84u as=0.42p ps=2.84u w=0.42u l=12u
X384 lo_i lo_bi_Py2 VSS VSS nfet_03v3 ad=1.25p pd=3.5u as=2.5p ps=7u w=2.5u l=0.28u
X385 lo_bi_x ls VDD VDD pfet_03v3 ad=0.3p pd=1.6u as=0.6p ps=3.2u w=0.6u l=0.28u
X386 VSS bbq_vb VSS VSS nfet_03v3 ad=24.57p pd=51.14u as=0 ps=0 w=24.57u l=10u
X387 bbq_g2p bbq_vgr bbq_vb bbq_vb pfet_03v3 ad=0.42p pd=2.84u as=0.42p ps=2.84u w=0.42u l=12u
X388 VSS lna_vcm VSS VSS nfet_03v3 ad=4.4235p pd=20.56u as=0 ps=0 w=9.83u l=10u
X389 li_tL nb VSS VSS nfet_03v3 ad=2p pd=6u as=0.9p ps=4.9u w=2u l=0.5u
X390 lo_bq_tb lo_bq_t VSS VSS nfet_03v3 ad=1.5p pd=5u as=1.5p ps=5u w=1.5u l=0.28u
X391 lq_mRpCa lq_mRpCa lq_gcp lq_gcp pfet_03v3 ad=0.42p pd=2.84u as=0.42p ps=2.84u w=0.42u l=1u
X392 bbi_o1p bi_n bbi_t1 VSS nfet_03v3 ad=10p pd=21u as=10p ps=21u w=20u l=1u
X393 lna_x2q_tail nb VSS VSS nfet_03v3 ad=5p pd=11u as=5p ps=11u w=10u l=0.5u
X394 lo_bq_ta lo_bq_t VSS VSS nfet_03v3 ad=0.5p pd=3u as=0.5p ps=3u w=0.5u l=0.28u
X395 VSS oq_p VSS VSS nfet_03v3 ad=24.57p pd=51.14u as=0 ps=0 w=24.57u l=10u
X396 li_ca li_ca VDD VDD pfet_03v3 ad=1p pd=4u as=0.45p ps=2.9u w=1u l=0.5u
X397 lo_bq_x lsq VDD VDD pfet_03v3 ad=0.3p pd=1.6u as=0.6p ps=3.2u w=0.6u l=0.28u
X398 VDD lo_bi_Py1 lo_bi_Py2 VDD pfet_03v3 ad=2.5p pd=7u as=1.25p ps=3.5u w=2.5u l=0.28u
X399 q_q lq_cq VSS VSS nfet_03v3 ad=2p pd=6u as=0.9p ps=4.9u w=2u l=0.28u
X400 lna_tail inp lna_outn VSS nfet_03v3 ad=5p pd=11u as=5p ps=11u w=10u l=0.28u
X401 VSS nb lna_x2q_tail VSS nfet_03v3 ad=10p pd=22u as=5p ps=11u w=10u l=0.5u
X402 li_ct li_gcn li_cb VSS nfet_03v3 ad=1p pd=3u as=1p ps=3u w=2u l=0.5u
X403 lna_outp inn lna_tail VSS nfet_03v3 ad=5p pd=11u as=5p ps=11u w=10u l=0.28u
X404 VDD lo_bq_Py1 lo_bq_Py2 VDD pfet_03v3 ad=2.5p pd=7u as=1.25p ps=3.5u w=2.5u l=0.28u
X405 bbq_t1 bq_n bbq_o1p VSS nfet_03v3 ad=10p pd=21u as=10p ps=21u w=20u l=1u
X406 bbi_mRp2b bbi_mRp2b bbi_vb bbi_vb pfet_03v3 ad=0.42p pd=2.84u as=0.42p ps=2.84u w=0.42u l=1u
X407 oq_p bbq_g3n bbq_t3 VSS nfet_03v3 ad=2p pd=5u as=2p ps=5u w=4u l=1u
X408 VSS bq_n VSS VSS nfet_03v3 ad=2.2932p pd=8.75u as=0 ps=0 w=8.19u l=5u
X409 VDD bbi_o2p VSS ppolyf_u_1k r_width=1u r_length=0.2m
X410 VSS lo_lq_D1qb lo_lq_q1 VSS nfet_03v3 ad=0.27p pd=2.1u as=0.6p ps=3.2u w=0.6u l=0.28u
X411 lna_tail inn lna_outp VSS nfet_03v3 ad=5p pd=11u as=5p ps=11u w=10u l=0.28u
X412 nb nb VSS VSS nfet_03v3 ad=2p pd=6u as=0.9p ps=4.9u w=2u l=0.5u
X413 VSS lo_bi_Ny2 lob_i VSS nfet_03v3 ad=2.5p pd=7u as=1.25p ps=3.5u w=2.5u l=0.28u
X414 bbq_o1n bq_p bbq_t1 VSS nfet_03v3 ad=10p pd=21u as=10p ps=21u w=20u l=1u
X415 lna_outn inp lna_tail VSS nfet_03v3 ad=5p pd=11u as=5p ps=11u w=10u l=0.28u
X416 bbi_t1 bi_p bbi_o1n VSS nfet_03v3 ad=10p pd=21u as=10p ps=21u w=20u l=1u
X417 lna_x2i_tail lna_outp ri_n VSS nfet_03v3 ad=5p pd=11u as=5p ps=11u w=10u l=0.28u
X418 lq_vgr nb VSS VSS nfet_03v3 ad=0.42p pd=2.84u as=0.42p ps=2.84u w=0.42u l=50u
X419 bbi_o2p bbi_g3p bbi_o2p bbi_o2p pfet_03v3 ad=12.285p pd=26.57u as=0 ps=0 w=12.285u l=10u
X420 VSS bbi_o2n VSS VSS nfet_03v3 ad=12.285p pd=25.57u as=0 ps=0 w=24.57u l=10u
X421 bbi_t1 bi_p bbi_o1n VSS nfet_03v3 ad=10p pd=21u as=20p ps=42u w=20u l=1u
X422 VSS nb lna_x2q_tail VSS nfet_03v3 ad=5p pd=11u as=5p ps=11u w=10u l=0.5u
X423 VSS bq_n VSS VSS nfet_03v3 ad=3.6855p pd=17.28u as=0 ps=0 w=8.19u l=5u
X424 bi_n lo_i ri_n VSS nfet_03v3 ad=4p pd=9u as=4p ps=9u w=8u l=0.28u
X425 bbq_o1p bq_n bbq_t1 VSS nfet_03v3 ad=10p pd=21u as=10p ps=21u w=20u l=1u
X426 b_vh b_n2 b_n2 VDD pfet_03v3 ad=2p pd=5u as=2p ps=5u w=4u l=1u
X427 VDD lo_bi_Ny2 lob_i VDD pfet_03v3 ad=2.0825p pd=5.165u as=4.165p ps=10.33u w=4.165u l=0.28u
X428 bbq_t2 bbq_g2n bbq_o2p VSS nfet_03v3 ad=2p pd=5u as=2p ps=5u w=4u l=1u
X429 li_mRpLa li_mRpLa li_glp li_glp pfet_03v3 ad=0.42p pd=2.84u as=0.42p ps=2.84u w=0.42u l=1u
X430 lna_tail nb VSS VSS nfet_03v3 ad=5p pd=11u as=2.8p ps=10.56u w=10u l=0.5u
X431 VSS lo_lq_lf VSS VSS nfet_03v3 ad=7.2p pd=32.9u as=0 ps=0 w=16u l=16u
X432 li_vgr li_vgr li_vb li_vb pfet_03v3 ad=4p pd=10u as=4p ps=10u w=4u l=1u
X433 li_mRpLa li_mRpLa li_vb li_vb pfet_03v3 ad=0.42p pd=2.84u as=0.42p ps=2.84u w=0.42u l=1u
X434 VSS nb lna_tail VSS nfet_03v3 ad=2.8p pd=10.56u as=5p ps=11u w=10u l=0.5u
X435 VSS lo_bq_Ny2 lob_q VSS nfet_03v3 ad=2.5p pd=7u as=1.25p ps=3.5u w=2.5u l=0.28u
X436 VDD en lo_bi_Py0 VDD pfet_03v3 ad=1.25p pd=4.5u as=0.625p ps=2.25u w=1.25u l=0.28u
X437 bbq_t3 bbq_g3p oq_n VSS nfet_03v3 ad=2p pd=5u as=4p ps=10u w=4u l=1u
X438 oi_n bbi_g3p bbi_t3 VSS nfet_03v3 ad=4p pd=10u as=2p ps=5u w=4u l=1u
X439 bbi_t1 nb VSS VSS nfet_03v3 ad=4p pd=9u as=3.6p ps=16.9u w=8u l=0.5u
X440 VDD lo_bq_Ny2 lob_q VDD pfet_03v3 ad=2.0825p pd=5.165u as=4.165p ps=10.33u w=4.165u l=0.28u
X441 lo_bi_a lo_bi_b VSS VSS nfet_03v3 ad=0.42p pd=2.84u as=0.42p ps=2.84u w=0.42u l=0.28u
X442 bbq_t1 bq_n bbq_o1p VSS nfet_03v3 ad=10p pd=21u as=10p ps=21u w=20u l=1u
X443 lna_x2i_tail nb VSS VSS nfet_03v3 ad=5p pd=11u as=2.8p ps=10.56u w=10u l=0.5u
X444 bbi_mRp3a bbi_mRp3a bbi_g3p bbi_g3p pfet_03v3 ad=0.42p pd=2.84u as=0.42p ps=2.84u w=0.42u l=1u
X445 VDD en lo_bq_Py0 VDD pfet_03v3 ad=1.25p pd=4.5u as=0.625p ps=2.25u w=1.25u l=0.28u
X446 VDD lo_bi_Ny2 lob_i VDD pfet_03v3 ad=4.165p pd=10.33u as=2.0825p ps=5.165u w=4.165u l=0.28u
X447 bbi_o1n bi_p bbi_t1 VSS nfet_03v3 ad=10p pd=21u as=10p ps=21u w=20u l=1u
X448 VSS nb lna_tail VSS nfet_03v3 ad=2.8p pd=10.56u as=5p ps=11u w=10u l=0.5u
X449 bbi_mRp3b bbi_mRp3b bbi_g3n bbi_g3n pfet_03v3 ad=0.42p pd=2.84u as=0.42p ps=2.84u w=0.42u l=1u
X450 bbi_o1n bbi_g2n bbi_o1n bbi_o1n pfet_03v3 ad=12.285p pd=26.57u as=0 ps=0 w=12.285u l=10u
X451 VDD li_ln VSS ppolyf_u r_width=1u r_length=28.56u
X452 ri_p lob_i bi_n VSS nfet_03v3 ad=8p pd=18u as=4p ps=9u w=8u l=0.28u
X453 bbq_t3 nb VSS VSS nfet_03v3 ad=0.8p pd=3.6u as=0.36p ps=2.5u w=0.8u l=0.5u
X454 lna_tail nb VSS VSS nfet_03v3 ad=5p pd=11u as=2.8p ps=10.56u w=10u l=0.5u
X455 VSS lna_vcm VSS VSS nfet_03v3 ad=2.7524p pd=10.39u as=0 ps=0 w=9.83u l=10u
X456 VSS lo_lq_vq VSS VSS nfet_03v3 ad=3.6855p pd=17.28u as=0 ps=0 w=8.19u l=10u
X457 VDD lo_bq_Ny2 lob_q VDD pfet_03v3 ad=4.165p pd=10.33u as=2.0825p ps=5.165u w=4.165u l=0.28u
X458 li_cq li_co VSS VSS nfet_03v3 ad=0.5p pd=3u as=0.225p ps=1.9u w=0.5u l=0.28u
X459 VDD bbi_o1p VSS ppolyf_u r_width=2u r_length=57.14u
X460 lq_mRpCb lq_mRpCb lq_vb lq_vb pfet_03v3 ad=0.42p pd=2.84u as=0.42p ps=2.84u w=0.42u l=1u
X461 bbi_o1n bi_p bbi_t1 VSS nfet_03v3 ad=10p pd=21u as=10p ps=21u w=20u l=1u
X462 bbq_t1 bq_p bbq_o1n VSS nfet_03v3 ad=10p pd=21u as=10p ps=21u w=20u l=1u
X463 VSS lo_lq_lg lo_lq_lo1 VSS nfet_03v3 ad=0.1686p pd=1.74u as=0.5448p ps=5.16u w=0.22u l=0.28u
X464 lna_tail inp lna_outn VSS nfet_03v3 ad=5p pd=11u as=5p ps=11u w=10u l=0.28u
X465 VSS nb lna_x2i_tail VSS nfet_03v3 ad=2.8p pd=10.56u as=5p ps=11u w=10u l=0.5u
X466 lq_cb lq_ca VDD VDD pfet_03v3 ad=1.7p pd=5.4u as=0.765p ps=4.3u w=1.7u l=0.5u
X467 li_co li_cx VSS VSS nfet_03v3 ad=1p pd=4u as=0.45p ps=2.9u w=1u l=0.5u
X468 bbi_vb bbi_vbt VSS ppolyf_u_1k r_width=1u r_length=0.15002m
X469 lna_vt enb VDD VDD pfet_03v3 ad=2p pd=6u as=2p ps=6u w=2u l=0.28u
X470 VSS lna_vcm VSS VSS nfet_03v3 ad=2.7524p pd=10.39u as=0 ps=0 w=9.83u l=10u
X471 VSS lo_lq_vq VSS VSS nfet_03v3 ad=2.2932p pd=8.75u as=0 ps=0 w=8.19u l=10u
X472 VDD lna_outn VSS ppolyf_u r_width=4u r_length=9.14u
X473 VSS bbq_o2p VSS VSS nfet_03v3 ad=12.285p pd=25.57u as=0 ps=0 w=24.57u l=10u
X474 VSS bi_n VSS VSS nfet_03v3 ad=2.2932p pd=8.75u as=0 ps=0 w=8.19u l=5u
X475 li_ln li_gcn li_ln li_ln pfet_03v3 ad=12.285p pd=26.57u as=24.57p ps=53.14u w=12.285u l=10u
X476 VSS VDD VSS VSS nfet_03v3 ad=5.4p pd=24.9u as=0 ps=0 w=12u l=10u
X477 lna_tail inn lna_outp VSS nfet_03v3 ad=5p pd=11u as=5p ps=11u w=10u l=0.28u
X478 li_vb li_vbt VSS ppolyf_u_1k r_width=1u r_length=0.15m
X479 bbi_t1 bi_n bbi_o1p VSS nfet_03v3 ad=10p pd=21u as=10p ps=21u w=20u l=1u
X480 VDD en lo_bi_x VDD pfet_03v3 ad=0.6p pd=3.2u as=0.3p ps=1.6u w=0.6u l=0.28u
X481 bbi_t2 bbi_g2n bbi_o2p VSS nfet_03v3 ad=2p pd=5u as=2p ps=5u w=4u l=1u
X482 lna_tail inp lna_outn VSS nfet_03v3 ad=5p pd=11u as=5p ps=11u w=10u l=0.28u
X483 lna_tail inp lna_outn VSS nfet_03v3 ad=5p pd=11u as=10p ps=22u w=10u l=0.28u
X484 lo_bi_tb lo_bi_t VSS VSS nfet_03v3 ad=1.5p pd=5u as=1.5p ps=5u w=1.5u l=0.28u
X485 lna_x2q_tail lna_outn rq_p VSS nfet_03v3 ad=5p pd=11u as=5p ps=11u w=10u l=0.28u
X486 lo_bq_b lo_bq_a VSS VSS nfet_03v3 ad=0.42p pd=2.84u as=0.42p ps=2.84u w=0.42u l=0.28u
X487 lq_ct lq_gcp lq_ca VSS nfet_03v3 ad=1p pd=3u as=2p ps=6u w=2u l=0.5u
X488 bbq_mRp2b bbq_mRp2b bbq_vb bbq_vb pfet_03v3 ad=0.42p pd=2.84u as=0.42p ps=2.84u w=0.42u l=1u
X489 VDD en lo_bq_x VDD pfet_03v3 ad=0.6p pd=3.2u as=0.3p ps=1.6u w=0.6u l=0.28u
X490 ri_n lna_outp lna_x2i_tail VSS nfet_03v3 ad=5p pd=11u as=5p ps=11u w=10u l=0.28u
X491 ri_p lna_outn lna_x2i_tail VSS nfet_03v3 ad=5p pd=11u as=5p ps=11u w=10u l=0.28u
X492 VDD bbi_o2n VSS ppolyf_u_1k r_width=1u r_length=0.2m
X493 VSS nb lna_x2i_tail VSS nfet_03v3 ad=4.5p pd=20.9u as=5p ps=11u w=10u l=0.5u
X494 VSS VDD VSS VSS nfet_03v3 ad=3.36p pd=12.56u as=0 ps=0 w=12u l=10u
X495 li_mRpCa li_mRpCa li_vb li_vb pfet_03v3 ad=0.42p pd=2.84u as=0.42p ps=2.84u w=0.42u l=1u
X496 lq_co lq_ca VDD VDD pfet_03v3 ad=2p pd=6u as=0.9p ps=4.9u w=2u l=0.5u
X497 bbi_o1n bi_p bbi_t1 VSS nfet_03v3 ad=10p pd=21u as=10p ps=21u w=20u l=1u
X498 enb en VSS VSS nfet_03v3 ad=0.42p pd=2.84u as=0.189p ps=1.74u w=0.42u l=0.28u
X499 lo_i lo_bi_Py2 VDD VDD pfet_03v3 ad=2.0825p pd=5.165u as=4.165p ps=10.33u w=4.165u l=0.28u
X500 VSS oq_n VSS VSS nfet_03v3 ad=12.285p pd=25.57u as=0 ps=0 w=24.57u l=10u
X501 lo_lq_vq lo_lq_lg lo_lq_lo1 lo_lq_vq pfet_03v3 ad=0.225p pd=1.9u as=1.1p ps=5.4u w=0.5u l=0.28u
X502 bbq_t1 bq_p bbq_o1n VSS nfet_03v3 ad=10p pd=21u as=10p ps=21u w=20u l=1u
X503 lna_x2q_tail lna_outn rq_p VSS nfet_03v3 ad=5p pd=11u as=5p ps=11u w=10u l=0.28u
X504 rq_n lob_q bq_p VSS nfet_03v3 ad=4p pd=9u as=4p ps=9u w=8u l=0.28u
X505 lo_q lo_bq_Py2 VDD VDD pfet_03v3 ad=2.0825p pd=5.165u as=4.165p ps=10.33u w=4.165u l=0.28u
X506 VSS oi_p VSS VSS nfet_03v3 ad=12.285p pd=25.57u as=0 ps=0 w=24.57u l=10u
X507 bbi_mRp2b bbi_mRp2b bbi_g2n bbi_g2n pfet_03v3 ad=0.42p pd=2.84u as=0.42p ps=2.84u w=0.42u l=1u
X508 lo_bi_t lo_bi_x VDD VDD pfet_03v3 ad=1.05p pd=4.1u as=1.05p ps=4.1u w=1.05u l=0.28u
X509 li_ca li_cb VDD VDD pfet_03v3 ad=1.7p pd=5.4u as=0.765p ps=4.3u w=1.7u l=0.5u
X510 lo_lq_tt lsq lo_lq_vq lo_lq_vq pfet_03v3 ad=1.05p pd=4.1u as=0.4725p ps=3u w=1.05u l=0.28u
X511 ri_p VDD VSS ppolyf_u r_width=2u r_length=9.14u
X512 lna_outn inp lna_tail VSS nfet_03v3 ad=10p pd=22u as=5p ps=11u w=10u l=0.28u
X513 b_x enb VSS VSS nfet_03v3 ad=0.42p pd=2.84u as=0.189p ps=1.74u w=0.42u l=0.28u
X514 lna_tail inn lna_outp VSS nfet_03v3 ad=5p pd=11u as=5p ps=11u w=10u l=0.28u
X515 b_n2 nb b_nr VSS nfet_03v3 ad=2p pd=6u as=1p ps=3u w=2u l=0.5u
X516 VSS bbi_o2p VSS VSS nfet_03v3 ad=12.285p pd=25.57u as=0 ps=0 w=24.57u l=10u
X517 lna_tail nb VSS VSS nfet_03v3 ad=5p pd=11u as=2.8p ps=10.56u w=10u l=0.5u
X518 lo_bq_t lo_bq_x VDD VDD pfet_03v3 ad=1.05p pd=4.1u as=1.05p ps=4.1u w=1.05u l=0.28u
X519 bbi_t1 bi_n bbi_o1p VSS nfet_03v3 ad=10p pd=21u as=10p ps=21u w=20u l=1u
X520 lq_mRpLa lq_mRpLa lq_glp lq_glp pfet_03v3 ad=0.42p pd=2.84u as=0.42p ps=2.84u w=0.42u l=1u
X521 lq_mRpLa lq_mRpLa lq_vb lq_vb pfet_03v3 ad=0.42p pd=2.84u as=0.42p ps=2.84u w=0.42u l=1u
X522 nb b_x b_n2 VSS nfet_03v3 ad=1p pd=4u as=1p ps=4u w=1u l=0.28u
X523 lq_tL lq_gln lq_lp VSS nfet_03v3 ad=2p pd=5u as=2p ps=5u w=4u l=0.5u
X524 lna_outp inn lna_tail VSS nfet_03v3 ad=5p pd=11u as=5p ps=11u w=10u l=0.28u
X525 b_vh enb VDD VDD pfet_03v3 ad=4p pd=10u as=1.8p ps=8.9u w=4u l=0.28u
X526 lq_ca lq_gcp lq_ct VSS nfet_03v3 ad=2p pd=6u as=1p ps=3u w=2u l=0.5u
X527 bbi_vgr bbi_vgr bbi_vb bbi_vb pfet_03v3 ad=4p pd=10u as=4p ps=10u w=4u l=1u
X528 VSS oi_p VSS VSS nfet_03v3 ad=24.57p pd=51.14u as=0 ps=0 w=24.57u l=10u
X529 VSS en lo_bi_Pgs VSS nfet_03v3 ad=1p pd=4u as=0.28p ps=1.56u w=1u l=0.28u
X530 lob_i lo_bi_Ny2 VDD VDD pfet_03v3 ad=2.0825p pd=5.165u as=2.0825p ps=5.165u w=4.165u l=0.28u
X531 oi_p li_glp oi_p oi_p pfet_03v3 ad=12.285p pd=26.57u as=24.57p ps=53.14u w=12.285u l=10u
X532 bbi_g3p bbi_vgr bbi_vb bbi_vb pfet_03v3 ad=0.42p pd=2.84u as=0.42p ps=2.84u w=0.42u l=12u
X533 bbq_o1n bq_p bbq_t1 VSS nfet_03v3 ad=10p pd=21u as=10p ps=21u w=20u l=1u
X534 lna_outp inn lna_tail VSS nfet_03v3 ad=5p pd=11u as=5p ps=11u w=10u l=0.28u
X535 lq_glp lq_vgr lq_vb lq_vb pfet_03v3 ad=0.42p pd=2.84u as=0.42p ps=2.84u w=0.42u l=12u
X536 lna_tail nb VSS VSS nfet_03v3 ad=5p pd=11u as=4.5p ps=20.9u w=10u l=0.5u
X537 bq_n lob_q rq_n VDD pfet_03v3 ad=8p pd=17u as=8p ps=17u w=16u l=0.28u
X538 lna_outn inp lna_tail VSS nfet_03v3 ad=5p pd=11u as=5p ps=11u w=10u l=0.28u
X539 lob_q lo_bq_Ny2 VDD VDD pfet_03v3 ad=2.0825p pd=5.165u as=2.0825p ps=5.165u w=4.165u l=0.28u
X540 lna_tail inp lna_outn VSS nfet_03v3 ad=5p pd=11u as=5p ps=11u w=10u l=0.28u
X541 VSS oi_n VSS VSS nfet_03v3 ad=12.285p pd=25.57u as=0 ps=0 w=24.57u l=10u
X542 lna_tail nb VSS VSS nfet_03v3 ad=5p pd=11u as=2.8p ps=10.56u w=10u l=0.5u
X543 VDD oi_n VSS ppolyf_u_1k r_width=1u r_length=0.2m
X544 bbi_o1p bi_n bbi_t1 VSS nfet_03v3 ad=10p pd=21u as=10p ps=21u w=20u l=1u
X545 li_ct nb VSS VSS nfet_03v3 ad=2p pd=6u as=0.9p ps=4.9u w=2u l=0.5u
X546 ri_p lo_i bi_n VDD pfet_03v3 ad=16p pd=34u as=8p ps=17u w=16u l=0.28u
X547 li_tL li_gln li_lp VSS nfet_03v3 ad=2p pd=5u as=2p ps=5u w=4u l=0.5u
X548 lo_bi_Ny2 lo_bi_Ny1 VDD VDD pfet_03v3 ad=1.25p pd=3.5u as=2.5p ps=7u w=2.5u l=0.28u
X549 bbq_o2n bbq_g3n bbq_o2n bbq_o2n pfet_03v3 ad=6.1425p pd=13.285u as=0 ps=0 w=12.285u l=10u
X550 lna_tail inn lna_outp VSS nfet_03v3 ad=5p pd=11u as=5p ps=11u w=10u l=0.28u
X551 lna_x2q_tail lna_outn rq_p VSS nfet_03v3 ad=5p pd=11u as=5p ps=11u w=10u l=0.28u
X552 bbi_o1p bi_n bbi_t1 VSS nfet_03v3 ad=10p pd=21u as=10p ps=21u w=20u l=1u
X553 lo_bq_Ny2 lo_bq_Ny1 VDD VDD pfet_03v3 ad=1.25p pd=3.5u as=2.5p ps=7u w=2.5u l=0.28u
X554 bbq_t1 bq_n bbq_o1p VSS nfet_03v3 ad=10p pd=21u as=10p ps=21u w=20u l=1u
X555 lna_tail nb VSS VSS nfet_03v3 ad=5p pd=11u as=2.8p ps=10.56u w=10u l=0.5u
X556 VSS b_nr VSS ppolyf_u r_width=2u r_length=29.72u
X557 VSS en lo_bq_Pgs VSS nfet_03v3 ad=1p pd=4u as=0.28p ps=1.56u w=1u l=0.28u
X558 li_cb li_gcn li_ct VSS nfet_03v3 ad=1p pd=3u as=1p ps=3u w=2u l=0.5u
X559 VDD lq_lp VSS ppolyf_u r_width=1u r_length=28.56u
X560 bbi_o1p bbi_g2p bbi_o1p bbi_o1p pfet_03v3 ad=6.1425p pd=13.285u as=0 ps=0 w=12.285u l=10u
X561 VSS bi_n VSS VSS nfet_03v3 ad=3.6855p pd=17.28u as=0 ps=0 w=8.19u l=5u
X562 bbi_t1 bi_p bbi_o1n VSS nfet_03v3 ad=10p pd=21u as=10p ps=21u w=20u l=1u
X563 VSS bbq_o2n VSS VSS nfet_03v3 ad=12.285p pd=25.57u as=0 ps=0 w=24.57u l=10u
X564 lna_x2i_tail lna_outn ri_p VSS nfet_03v3 ad=5p pd=11u as=5p ps=11u w=10u l=0.28u
X565 oq_n bbq_g3p bbq_t3 VSS nfet_03v3 ad=4p pd=10u as=2p ps=5u w=4u l=1u
X566 lq_cb lq_cb VDD VDD pfet_03v3 ad=1p pd=4u as=0.45p ps=2.9u w=1u l=0.5u
X567 bbi_t3 nb VSS VSS nfet_03v3 ad=0.8p pd=3.6u as=0.36p ps=2.5u w=0.8u l=0.5u
X568 lna_outp inn lna_tail VSS nfet_03v3 ad=5p pd=11u as=5p ps=11u w=10u l=0.28u
X569 ri_n VDD VSS ppolyf_u r_width=2u r_length=9.14u
X570 bbi_vgr nb VSS VSS nfet_03v3 ad=0.42p pd=2.84u as=0.42p ps=2.84u w=0.42u l=50u
X571 bbi_t1 bi_p bbi_o1n VSS nfet_03v3 ad=10p pd=21u as=10p ps=21u w=20u l=1u
X572 bbq_o1p bq_n bbq_t1 VSS nfet_03v3 ad=10p pd=21u as=10p ps=21u w=20u l=1u
X573 bbq_o1p bq_n bbq_t1 VSS nfet_03v3 ad=10p pd=21u as=10p ps=21u w=20u l=1u
X574 lq_ln lq_gcn lq_ln lq_ln pfet_03v3 ad=12.285p pd=26.57u as=24.57p ps=53.14u w=12.285u l=10u
X575 VSS lq_vb VSS VSS nfet_03v3 ad=5.52825p pd=25.47u as=0 ps=0 w=12.285u l=10u
X576 bbi_o1p bi_n bbi_t1 VSS nfet_03v3 ad=10p pd=21u as=10p ps=21u w=20u l=1u
X577 VSS oq_p VSS VSS nfet_03v3 ad=12.285p pd=25.57u as=0 ps=0 w=24.57u l=10u
X578 lna_outn inp lna_tail VSS nfet_03v3 ad=5p pd=11u as=5p ps=11u w=10u l=0.28u
X579 VDD li_lp VSS ppolyf_u r_width=1u r_length=28.56u
X580 bbi_vb VSS VSS ppolyf_u_1k r_width=1u r_length=99.99u
X581 lna_outp inn lna_tail VSS nfet_03v3 ad=5p pd=11u as=5p ps=11u w=10u l=0.28u
X582 VSS bi_n VSS VSS nfet_03v3 ad=2.2932p pd=8.75u as=0 ps=0 w=8.19u l=5u
X583 VSS VDD VSS VSS nfet_03v3 ad=5.4p pd=24.9u as=0 ps=0 w=12u l=10u
X584 bbq_t1 bq_n bbq_o1p VSS nfet_03v3 ad=10p pd=21u as=10p ps=21u w=20u l=1u
C0 inp lna_x2i_tail 0
C1 oq_n bbq_o2p 1.56807f
C2 bbi_t3 bbi_g3p 2.91775f
C3 bbq_o1p VDD 1.62549f
C4 en lo_bq_Ny2 0
C5 nb lna_outp 0.32997f
C6 oq_n bbq_g2n 0.17948f
C7 en lo_bi_Pgs 0.00905f
C8 ri_n VDD 4.43941f
C9 nb lq_mRpCa 1.82097f
C10 ls bq_n 0.05175f
C11 nb li_gcn 0.46544f
C12 bbq_t3 bbq_vb 0.14106f
C13 bbq_g3p VDD 4.33045f
C14 lo_bi_ta nb 0
C15 bbq_mRp2b bbq_vb 0.57255f
C16 lo_bi_Py0 bq_n 0
C17 lo_bq_Py2 lo_bq_Py1 2.44938f
C18 en lo_bi_Ny2 0
C19 nb lq_glp 0.15007f
C20 lo_bi_Ny1 nb 0
C21 enb bbi_g2p 0.00127f
C22 lo_lq_q1 lsq 0.04689f
C23 li_mRpCb VDD 0.13847f
C24 lna_tail lna_vcm 0.60498f
C25 bq_p bq_n 18.0956f
C26 VDD lo_bq_Ny2 0.91604f
C27 lo_lq_D1qb a_47706_713# 0.07726f
C28 VDD lo_bi_Pgs 0
C29 nb li_glp 0.15007f
C30 lo_bq_a en 1.31385f
C31 bbi_t3 bbi_g3n 2.927f
C32 bbq_vbt bq_n 0.00951f
C33 rq_n bq_n 1.44397f
C34 lo_bq_g0s lo_q 0
C35 lo_bi_a lo_i 0.47966f
C36 lo_bq_Pgs lo_q 0
C37 en bq_n 0.05314f
C38 lo_bi_Ny2 VDD 0.916f
C39 lo_bi_Py1 lo_bi_b 0
C40 lsq lo_bq_ta 0.29598f
C41 oi_n bbi_vb 0.33016f
C42 bbi_mRp2a bbi_vbt 0.00601f
C43 lo_bi_b bi_p 0
C44 lo_lq_lo2 lo_lq_D1y 0.003f
C45 bbi_mRp2a VDD 0.04832f
C46 lq_co q_q 0.02598f
C47 oq_p bbq_t2 0.47994f
C48 nb bbi_g3p 0.17164f
C49 lo_bi_t bi_p 0
C50 bbi_mRp3a bbi_o2p 0.03426f
C51 enb li_gcp 0.00536f
C52 bbq_mRp2a bbq_vbt 0.00601f
C53 li_mRpLb VDD 0.03387f
C54 bbq_vgr oq_p 0.90342f
C55 lq_gln lq_gcp 0
C56 lna_outn lna_x2i_tail 5.79198f
C57 lo_bq_a VDD 0.76152f
C58 lo_lq_lo2 lo_lq_vq 0.39275f
C59 lo_lq_D1x a_48450_713# 0.00911f
C60 li_tL oi_p 0.00244f
C61 lo_bq_Py1 lo_q 0.14534f
C62 li_cb li_ct 0.22508f
C63 VDD bq_n 0.56333f
C64 li_gcp li_ln 2.31969f
C65 li_cq li_ca 0
C66 oq_n bbq_t2 1.43221f
C67 lq_ct lq_ln 0.12331f
C68 lo_lq_lg lo_lq_lf 0.22692f
C69 lo_bi_Ny0 bi_n 0
C70 bbq_vgr oq_n 6.2003f
C71 bbi_o2n bbi_vb 0.35264f
C72 a_48024_1776# lsq 0.02603f
C73 nb bbi_g3n 0.27085f
C74 lq_mRpCb lq_gcp 0.14475f
C75 oq_p bbq_t3 0.49853f
C76 VDD lo_lq_D1y 0
C77 nb lq_vb 4.64825f
C78 bbq_mRp2a VDD 0.04832f
C79 li_vbt li_gcp 0.00317f
C80 lq_cb lq_lp 0.8057f
C81 lo_lq_D1x lo_lq_lo1 0
C82 lo_lq_vq VDD 1.60425f
C83 bbi_t3 nb 2.98191f
C84 li_cq li_gcn 0
C85 nb q_i 0.11424f
C86 lo_bq_t lo_bq_x 1.7784f
C87 bbi_mRp3a VDD 0.1197f
C88 lq_ca lq_lp 0.95018f
C89 b_n2 nb 3.63931f
C90 lq_gcn q_q 0.0493f
C91 nb bbq_g2p 0.07889f
C92 bbq_t3 oq_n 0.87498f
C93 lq_cb VDD 1.08903f
C94 lq_cb lq_cq 0
C95 li_tL li_glp 0.64021f
C96 lo_bq_Ngs lo_bq_Ny0 0.07147f
C97 lo_bq_Py0 lo_bq_b 0.17687f
C98 lo_bq_Py2 bq_p 0.00487f
C99 lo_bi_g0s lo_i 0
C100 lq_ca VDD 0.9067f
C101 lq_ca lq_cq 0
C102 enb bbq_o2p 0.79436f
C103 lo_bq_t lo_bq_b 0.21425f
C104 bbi_o1n bbi_o2p 0.37415f
C105 oq_n bbq_t1 0.00386f
C106 lo_bq_Py2 en 0.7223f
C107 lq_gcn lq_gcp 1.16018f
C108 VDD li_cx 0.26162f
C109 lo_bi_Ny0 bi_p 0
C110 VDD lna_x2i_tail 0.44747f
C111 lna_outp ri_n 2.32216f
C112 bbq_o2n bbq_o2p 4.9399f
C113 bi_n ls 0
C114 li_ct li_ca 0.33596f
C115 lq_cb lq_vbt 0.00161f
C116 bi_n bbi_o2p 1.11728f
C117 bbi_mRp2a bbi_g2n 0.13427f
C118 bbi_mRp2a bbi_vgr 0.05312f
C119 bbq_o2n bbq_g2n 0.63356f
C120 bi_n lo_bi_Py0 0
C121 inp lna_vcm 0.28752f
C122 lo_bq_Py2 VDD 0.84617f
C123 lq_ca lq_vbt 0.02106f
C124 li_mRpCb li_gcn 0.54081f
C125 bi_n bq_p 0
C126 lna_tail enb 0
C127 lo_bq_Ngs lo_bq_b 0.00888f
C128 bq_p lo_q 2.23159f
C129 li_cb li_cx 0.17701f
C130 lo_bq_g0s lsq 0.00494f
C131 VDD li_vgr 1.93315f
C132 li_gcn li_ct 0.61274f
C133 inn lna_tail 21.6972f
C134 bbq_vbt bbq_vb 0.28747f
C135 lo_lq_D1qb lo_lq_lf 0.00156f
C136 lo_bq_Pgs lsq 0.00248f
C137 rq_n lo_q 1.14054f
C138 lq_gln lq_vgr 2.26794f
C139 lob_q lo_bq_Ny0 0.5145f
C140 inp ri_p 0
C141 lo_q lo_bq_tb 0.00378f
C142 bi_n en 0.01115f
C143 bbi_vbt bbi_o1n 1.19688f
C144 en lo_q 0.49285f
C145 bbi_o1n VDD 1.62614f
C146 lo_bq_Py0 lo_bq_a 1.46313f
C147 lo_bi_b lob_i 0.25839f
C148 lo_lq_lo2 lo_lq_lo1 1.04229f
C149 lo_bi_Ny1 lo_bi_Ny2 2.32672f
C150 lo_bq_t lo_bq_a 0.00509f
C151 bbq_mRp3b bbq_vb 0.42363f
C152 lo_bi_t lob_i 0.09542f
C153 li_cq q_i 1.44037f
C154 lna_x2q_tail lna_outn 8.15728f
C155 lob_q lo_bq_x 0.08182f
C156 bi_n bbi_vbt 0.00951f
C157 bbi_mRp2a bbi_mRp2b 0.14576f
C158 lo_bq_Py1 lsq 0.44552f
C159 lo_bi_Py1 ls 0.44552f
C160 lq_mRpCb lq_vgr 0.03293f
C161 ls bi_p 0
C162 bi_n VDD 1.16732f
C163 VDD bbq_vb 5.61364f
C164 lo_lq_D1x lsq 0.65684f
C165 VDD lo_q 2.36371f
C166 bbi_o2p bi_p 1.0729f
C167 lo_bi_Py1 lo_bi_Py0 1.276f
C168 bbi_mRp3a bbi_vgr 0.05207f
C169 lo_bi_Py0 bi_p 0
C170 bbi_mRp3b bbi_vb 0.42363f
C171 lna_vcm lna_outn 2.71659f
C172 bbi_mRp3a oi_p 2.19053f
C173 bbq_o1n bbq_g2p 2.57561f
C174 VDD li_co 0.40418f
C175 li_mRpLb li_glp 0.10842f
C176 li_lp VDD 1.6706f
C177 li_vb VDD 5.48011f
C178 lo_bi_Py1 bq_p 0
C179 lob_q lo_bq_b 0.25839f
C180 bbq_t2 bbq_o2n 0.56895f
C181 lq_gln lq_lp 4.11236f
C182 lo_bi_b enb 0
C183 bq_p bi_p 0
C184 lo_lq_lo1 VDD 0
C185 b_vh b_x 1.54113f
C186 bbq_vgr bbq_o2n 1.51266f
C187 lo_lq_D1qb lo_lq_q1 0.74328f
C188 nb lq_ct 0.94367f
C189 lq_tL lq_lp 0.40988f
C190 li_tL nb 0.95043f
C191 lo_bi_Py1 en 0.12279f
C192 lna_outn ri_p 6.25655f
C193 en bi_p 0.27035f
C194 lo_lq_lf lo_lq_q1 0
C195 lq_cb lq_ln 0.24663f
C196 lo_bi_a lo_bi_Pgs 0.00896f
C197 bbq_o1p bbq_g2p 4.53819f
C198 VDD lq_gln 1.67595f
C199 oi_n bbi_o2p 1.56807f
C200 oq_n lq_vgr 0
C201 ri_n lo_i 1.14054f
C202 rq_n lna_x2q_tail 3.85225f
C203 li_cb li_co 0
C204 bbq_g3p bbq_g2p 0.01549f
C205 li_cx li_ca 0.19538f
C206 lq_tL VDD 0.15562f
C207 li_cb li_lp 0.8057f
C208 VDD li_gln 1.67595f
C209 lq_gcn lq_vgr 3.17454f
C210 lq_ca lq_ln 0.33477f
C211 enb lq_gcp 0.00536f
C212 lob_q lo_bq_Ny2 4.35651f
C213 bbi_o1n bbi_o1p 6.02565f
C214 bbi_g2p bbi_vb 0.66867f
C215 bbi_vbt bi_p 0.00152f
C216 bbq_o1n nb 0.02579f
C217 bbq_t3 bbq_o2n 0.30481f
C218 lo_bi_Py1 VDD 0.565f
C219 lo_bi_x bi_n 0
C220 VDD bi_p 4.28848f
C221 lq_co VDD 0.40432f
C222 b_nr b_x 0.01134f
C223 lq_co lq_cq 1.35725f
C224 enb bbq_t1 0.21873f
C225 lob_i lo_bi_tb 0.48724f
C226 oq_p lq_lp 0.15192f
C227 bbq_g3n nb 0.27085f
C228 rq_n lna_vcm 0.43052f
C229 bbq_mRp2b bbq_o2n 0.00107f
C230 bbq_g3n bbq_mRp3a 0.1479f
C231 lq_mRpCb VDD 0.13847f
C232 lo_bi_Pgs lo_i 0
C233 oq_p bbq_mRp3b 1.22474f
C234 oq_n bq_p 0.01544f
C235 bi_n bbi_o1p 15.6107f
C236 li_gcn li_cx 0.01262f
C237 lna_outp lna_x2i_tail 5.04918f
C238 lq_vbt lq_gln 0.37516f
C239 bbq_o2n bbq_t1 0.48555f
C240 lna_x2q_tail VDD 0.44326f
C241 bbi_o2n bbi_o2p 4.9399f
C242 lo_bi_Ny0 lob_i 0.5145f
C243 bbq_o1p nb 0
C244 lo_bq_Py0 lo_bq_Py2 0
C245 lob_q lo_bq_a 0.0038f
C246 oq_p VDD 1.90898f
C247 bbi_vgr bbi_o1n 2.7789f
C248 bbi_o1n bbi_g2n 6.65711f
C249 nb ri_n 0.99456f
C250 lo_lq_D1qb a_48024_1776# 0.01794f
C251 bbi_mRp3a bbi_g3p 2.77518f
C252 bbq_g3p nb 0.17164f
C253 oq_n lq_lp 0.18927f
C254 lob_q bq_n 1.95104f
C255 bbq_g3p bbq_mRp3a 2.77518f
C256 oi_n VDD 2.10664f
C257 en ri_p 0.0945f
C258 lna_vcm VDD 0.90371f
C259 lo_lq_lf a_48024_1776# 0
C260 lq_mRpLb lq_gln 0.60267f
C261 lq_mRpLa lq_gln 0.14083f
C262 lq_gcn lq_lp 0.00459f
C263 lo_lq_lo2 lsq 0.96379f
C264 bq_p lsq 0.89094f
C265 inn inp 8.71578f
C266 lo_lq_vq aq 0.03342f
C267 nb li_mRpCb 0.01135f
C268 bq_n lo_i 0.00182f
C269 bi_n bbi_g2n 0.02783f
C270 bq_n bbq_g2p 0.02671f
C271 en b_x 0.03867f
C272 oq_n VDD 2.27427f
C273 li_gcn li_vgr 3.17454f
C274 lo_bq_tb lsq 0.03717f
C275 bbq_g2n bbq_o2p 4.3121f
C276 nb li_ct 0.94367f
C277 en lsq 1.88825f
C278 bbi_t1 bbi_o2p 0.41474f
C279 lo_bi_x bi_p 0
C280 lo_bi_Ny0 enb 0
C281 lq_gcn VDD 1.69489f
C282 VDD ri_p 3.67067f
C283 lq_gcn lq_cq 0
C284 oq_p lq_vbt 0.42476f
C285 bbi_mRp3a bbi_g3n 0.1479f
C286 nb lo_bi_Ny2 0
C287 li_lp oi_p 0.15192f
C288 VDD li_mRpCa 0.16896f
C289 bbq_mRp2a bbq_g2p 2.71538f
C290 li_ca li_co 0.34422f
C291 bbi_o1p bi_p 0.43338f
C292 li_lp li_ca 0.95018f
C293 lo_bq_Py0 lo_q 0.53184f
C294 bbi_o2n VDD 1.75028f
C295 b_x VDD 0.90637f
C296 li_vgr li_glp 0.11821f
C297 b_vh enb 0.25355f
C298 oi_n bbi_t2 1.43221f
C299 li_mRpLb nb 0.09398f
C300 VDD lsq 1.76264f
C301 lo_bq_t lo_q 0.28918f
C302 lo_bi_ta bi_n 0
C303 lob_i ls 0.58091f
C304 nb bq_n 1.47527f
C305 lo_bi_Ny1 bi_n 0
C306 enb lna_outn 0
C307 li_gcn li_co 0.00689f
C308 lq_gcn lq_vbt 0
C309 lo_bq_Ny0 lo_bq_b 1.41643f
C310 li_vb li_gcn 2.44488f
C311 li_lp li_gcn 0.00459f
C312 inn lna_outn 1.4769f
C313 oi_p li_gln 0.30002f
C314 li_mRpLa VDD 0.21658f
C315 bbi_g2n bi_p 0.02054f
C316 bbi_vgr bi_p 0.00137f
C317 oi_n bbi_o1p 0.00139f
C318 b_nr enb 0.04735f
C319 bbi_vbt bbi_t1 0.00159f
C320 bbi_t1 VDD 0.46847f
C321 lq_ln lq_gln 0.99875f
C322 q_i li_cx 0.00495f
C323 bbi_o2n bbi_t2 0.56895f
C324 lob_i en 0.0809f
C325 lo_bq_x lo_bq_b 0.06191f
C326 lq_tL lq_ln 0.51422f
C327 li_vb li_glp 3.18848f
C328 bbq_t2 bbq_o2p 0.3005f
C329 li_lp li_glp 0.74628f
C330 enb bbi_o2p 0.79436f
C331 rq_p lna_outn 8.87469f
C332 bbq_o1n bbq_o1p 6.02565f
C333 bbq_vgr bbq_o2p 0.23215f
C334 bbq_t2 bbq_g2n 2.93218f
C335 lo_bq_Ny0 lo_bq_Ny2 0.00506f
C336 lq_glp lq_gln 0.84592f
C337 li_gcn li_gln 0
C338 nb lq_cb 0.10392f
C339 bbq_vgr bbq_g2n 1.6135f
C340 oi_n bbi_vgr 6.2003f
C341 oi_n bbi_g2n 0.17948f
C342 lq_tL lq_glp 0.64021f
C343 lo_bi_ta bi_p 0
C344 oi_n oi_p 10.4495f
C345 ls lo_bi_Py2 0.67392f
C346 bq_p enb 0.39919f
C347 lob_i VDD 1.73305f
C348 bbq_vbt enb 0.62326f
C349 bbi_o2n bbi_o1p 0.0821f
C350 bbq_g3n bbq_g3p 0.34872f
C351 lq_mRpCb lq_mRpCa 0.76885f
C352 q_i li_vgr 0.11145f
C353 lq_ca nb 0.15947f
C354 lob_i lo_bi_Ngs 0.00392f
C355 rq_n enb 0
C356 lo_bi_Ny1 bi_p 0
C357 lo_bi_Py0 lo_bi_Py2 0
C358 bbi_t1 bbi_t2 0.003f
C359 bi_n lo_bi_a 0
C360 lo_lq_lg lo_lq_lo2 0.00588f
C361 lo_lq_D1qb lo_lq_D1x 0.70987f
C362 oq_p lq_ln 0.48261f
C363 en enb 6.53665f
C364 li_glp li_gln 0.84592f
C365 lna_x2q_tail lna_outp 7.58093f
C366 rq_n lna_vt 0.13876f
C367 bbq_t3 bbq_o2p 0
C368 enb lq_lp 0.05f
C369 bbq_o2n bq_p 1.03194f
C370 bq_p lo_bi_Py2 0.00967f
C371 nb lna_x2i_tail 4.58476f
C372 bbq_mRp2b bbq_o2p 0.58102f
C373 lna_outp lna_vcm 0.37213f
C374 bbq_mRp2b bbq_g2n 0.62129f
C375 lob_q lo_q 2.59148f
C376 oq_p lq_glp 2.16317f
C377 bq_p rq_p 2.20237f
C378 en lo_bi_Py2 0.72059f
C379 bbi_vgr bbi_o2n 1.51266f
C380 bbi_o2n bbi_g2n 0.63356f
C381 bbi_vbt enb 0.62326f
C382 VDD lo_lq_tt 0.00269f
C383 oq_n lq_ln 0.93324f
C384 enb VDD 13.4644f
C385 bbq_o2p bbq_t1 0.41474f
C386 lo_bq_a lo_bq_x 0
C387 bbi_t1 bbi_o1p 10.4824f
C388 bbi_o2n oi_p 2.54324f
C389 rq_n rq_p 3.6498f
C390 bi_n lo_i 1.27603f
C391 inn VDD 0.51493f
C392 bbq_vb bbq_g2p 0.66867f
C393 ri_n lo_bq_Ny2 0
C394 bbq_g2n bbq_t1 0.01151f
C395 lq_gcn lq_ln 4.21834f
C396 lq_cb lq_cx 0.17701f
C397 lna_vt VDD 0.26026f
C398 q_i li_co 0.02598f
C399 li_vb q_i 0.24451f
C400 VDD li_ln 1.63445f
C401 nb li_vgr 0.35015f
C402 lna_outp ri_p 0.18626f
C403 bbq_o1n bq_n 0.54853f
C404 lo_lq_lg VDD 0.00201f
C405 lq_gcn lq_mRpCa 0.26877f
C406 bbq_o2n VDD 1.75028f
C407 bbi_g2p bbi_o2p 2.6676f
C408 oi_n li_glp 0.1613f
C409 VDD lo_bi_Py2 0.84617f
C410 lo_bi_x lob_i 0.08182f
C411 oq_n lq_glp 0.1613f
C412 lq_gln lq_vb 2.65772f
C413 lo_bq_a lo_bq_b 2.81922f
C414 bbi_mRp3b VDD 0.14807f
C415 lq_ca lq_cx 0.19538f
C416 nb bbi_o1n 0.02579f
C417 li_gcn li_mRpCa 0.26877f
C418 bbq_vgr bbq_t2 0
C419 lo_bq_Py0 lsq 0.0923f
C420 lo_bi_Py1 lo_bi_a 0
C421 lo_bi_a bi_p 0
C422 bbi_vgr bbi_t1 0.03745f
C423 li_cb enb 0.00333f
C424 bbi_g2n bbi_t1 0.01151f
C425 lq_ct lq_cb 0.22508f
C426 VDD rq_p 2.73002f
C427 lo_bq_t lsq 0.09656f
C428 li_vbt VDD 0.67806f
C429 bbq_o1n bbq_mRp2a 0.04266f
C430 enb lq_vbt 0.99337f
C431 oi_n bbi_g3p 3.04668f
C432 lo_lq_D1x lo_lq_q1 0
C433 bbq_o1p bq_n 15.6107f
C434 bi_n nb 7.33556f
C435 li_cb li_ln 0.24663f
C436 lq_ca lq_ct 0.33596f
C437 bbi_o2n bbi_mRp2b 0.00107f
C438 lq_mRpCb lq_vb 0.39812f
C439 nb bbq_vb 2.5559f
C440 bbq_mRp3a bbq_vb 0.68743f
C441 bbq_t3 bbq_t2 0.00372f
C442 lo_bi_Py1 lo_i 0.14534f
C443 nb li_lp 0.15624f
C444 nb li_vb 4.64825f
C445 bi_p lo_i 2.27136f
C446 lo_bi_b lo_bi_t 0.21425f
C447 lo_lq_D1qb lo_lq_lo2 0.02485f
C448 li_cb li_vbt 0.00161f
C449 bbi_vbt bbi_g2p 1.35765f
C450 oi_n bbi_g3n 0.10389f
C451 li_cq li_cx 0
C452 bbi_g2p VDD 2.40668f
C453 bbq_vgr bbq_mRp2b 0.00978f
C454 enb bbi_o1p 0.20141f
C455 lo_lq_lf lo_lq_lo2 0
C456 lna_tail inp 18.8461f
C457 bbi_o2n bbi_g3p 0.12772f
C458 bbq_t2 bbq_t1 0.003f
C459 oi_n bbi_t3 0.87498f
C460 bbq_vgr bbq_t1 0.03745f
C461 oq_p bbq_g2p 0.10829f
C462 nb lq_gln 0.20704f
C463 li_mRpLa li_glp 2.72864f
C464 lq_tL nb 0.95043f
C465 q_q lq_gcp 0.05927f
C466 nb li_gln 0.20704f
C467 lq_gcn lq_vb 2.44488f
C468 lo_lq_D1x a_48024_1776# 0.14135f
C469 lo_bi_Py1 nb 0
C470 lo_bi_ta lob_i 0.02078f
C471 bbi_vgr enb 0.00769f
C472 nb bi_p 0.09552f
C473 li_gcp VDD 1.6543f
C474 lo_lq_D1qb VDD 0
C475 enb oi_p 0.07459f
C476 bbi_g3n bbi_o2n 6.81759f
C477 oq_n bbq_g2p 0.23654f
C478 lo_bi_Ny1 lob_i 0.20682f
C479 lq_mRpCb nb 0.01135f
C480 bbi_g2p bbi_t2 2.90297f
C481 enb li_ca 0.00985f
C482 lo_lq_lf VDD 0.0017f
C483 ri_n lna_x2i_tail 3.91883f
C484 oi_p li_ln 0.48261f
C485 ri_p lo_i 1.12024f
C486 q_i li_mRpCa 0.062f
C487 bbi_t3 bbi_o2n 0.30481f
C488 lna_x2q_tail nb 6.97815f
C489 bbi_mRp3b bbi_vgr 0.0027f
C490 li_ca li_ln 0.33477f
C491 enb lq_ln 0.10666f
C492 oq_p nb 1.70903f
C493 lob_q lsq 0.58091f
C494 b_n2 b_x 0.42354f
C495 bbi_mRp3b oi_p 1.22474f
C496 oq_p bbq_mRp3a 2.19053f
C497 lna_outp enb 0
C498 lna_tail lna_outn 25.3551f
C499 lo_bi_b lo_bi_tb 0.80645f
C500 oi_n nb 5.01967f
C501 li_cb li_gcp 0.40553f
C502 li_gcn enb 0.00488f
C503 inn lna_outp 21.4308f
C504 nb lna_vcm 6.11363f
C505 bq_p bbq_o2p 1.0729f
C506 bbi_o1p bbi_g2p 4.53819f
C507 li_vbt oi_p 0.42476f
C508 lo_bi_t lo_bi_tb 1.34876f
C509 li_tL li_lp 0.40988f
C510 li_vbt li_ca 0.02106f
C511 bbq_g2n bq_p 0.02054f
C512 lq_glp enb 0.00176f
C513 lo_bi_Ny1 enb 0
C514 lo_bq_x lo_q 0.06208f
C515 li_cq li_co 1.35725f
C516 oq_n nb 6.77501f
C517 li_cq li_vb 0.00355f
C518 li_gcn li_ln 4.21834f
C519 lo_bi_b lo_bi_Ny0 1.41643f
C520 bbq_o1n bbq_vb 0.18862f
C521 oq_n bbq_mRp3a 0.00909f
C522 lo_lq_vq lo_lq_D1y 0.51666f
C523 lq_co lq_cx 0.28525f
C524 lq_gcn nb 0.46544f
C525 enb li_glp 0.00176f
C526 nb ri_p 0.9629f
C527 bbq_g3n bbq_vb 0.60573f
C528 nb li_mRpCa 1.82097f
C529 lna_outp rq_p 0.13055f
C530 li_mRpCb li_vgr 0.03293f
C531 en lo_bq_ta 0.07314f
C532 lob_i lo_bi_a 0.0038f
C533 lo_bq_b lo_q 0.13724f
C534 bbi_vgr bbi_g2p 0.18549f
C535 bbi_g2n bbi_g2p 4.72021f
C536 li_gcn li_vbt 0
C537 nb bbi_o2n 0.53721f
C538 li_glp li_ln 2.62696f
C539 nb b_x 2.18179f
C540 li_tL li_gln 0.66214f
C541 VDD bbq_o2p 2.48834f
C542 bbi_g2p oi_p 0.10829f
C543 bbq_o1p bbq_vb 0.14015f
C544 bi_n ri_n 1.44397f
C545 bbi_o2p bbi_vb 1.28735f
C546 bbq_g2n VDD 1.86961f
C547 lo_bq_a lo_bq_Py2 0
C548 bbq_g3p bbq_vb 0.83647f
C549 VDD lo_bq_ta 0.33639f
C550 lo_bq_Py2 bq_n 0.00141f
C551 li_vbt li_glp 0.87545f
C552 li_mRpLb li_vgr 1.38037f
C553 bbi_mRp2a bbi_o1n 0.04266f
C554 lob_i lo_i 2.62395f
C555 li_mRpLa nb 0.13287f
C556 bbi_mRp3b bbi_g3p 0.14588f
C557 lq_ca lq_cb 1.75008f
C558 nb bbi_t1 0.70522f
C559 li_mRpCb li_vb 0.39812f
C560 q_q lq_vgr 0.11145f
C561 lo_bi_b ls 1.6034f
C562 lq_gcn lq_cx 0.01262f
C563 lna_tail VDD 0.284f
C564 bi_n lo_bi_Ny2 0
C565 li_gcp li_ca 1.11631f
C566 lo_lq_lg aq 1.98512f
C567 li_tL oi_n 0.77929f
C568 bbq_vgr bq_p 0.00137f
C569 li_lp li_ct 0.00147f
C570 bbi_g2p bbi_mRp2b 0.62517f
C571 lo_bi_b lo_bi_Py0 0.17687f
C572 lo_bi_t ls 0.09656f
C573 bbq_vgr bbq_vbt 0.08774f
C574 lo_bi_a lo_bi_Py2 0
C575 lo_bi_Ny0 lo_bi_tb 0.06857f
C576 lo_bq_a lo_q 0.47966f
C577 b_n2 enb 0.11728f
C578 bbi_vbt bbi_vb 0.28747f
C579 bbi_mRp3b bbi_g3n 0.50302f
C580 VDD bbi_vb 5.61364f
C581 lq_vgr lq_gcp 3.10457f
C582 lq_gcn lq_ct 0.61274f
C583 enb bbq_g2p 0.00127f
C584 ri_n bi_p 3.73479f
C585 bi_n bq_n 0
C586 bbq_g3n oq_p 3.27704f
C587 bq_n lo_q 1.23189f
C588 li_mRpLb li_vb 0.73361f
C589 li_gcn li_gcp 1.16018f
C590 bbq_vgr bbq_mRp3b 0.0027f
C591 lo_bi_b en 2.94909f
C592 lo_lq_D1y a_48450_713# 0.07136f
C593 bbi_g2p bbi_g3p 0.01549f
C594 lob_i lo_bi_g0s 0.00261f
C595 bbq_o2n bbq_g2p 3.24838f
C596 bbq_o1n oq_n 0.00225f
C597 lo_bi_t en 1.04578f
C598 lo_bi_Py2 lo_i 3.02187f
C599 bbq_vgr VDD 8.70759f
C600 lob_q rq_p 1.13241f
C601 inp lna_outn 18.4613f
C602 lo_lq_vq a_48450_713# 0.00409f
C603 oq_p bbq_g3p 1.08101f
C604 bbq_g3n oq_n 0.10389f
C605 bbq_mRp2a bbq_vb 3.04322f
C606 li_gcp li_glp 0
C607 lo_bi_b VDD 1.52213f
C608 lo_bi_Ny2 bi_p 0
C609 bq_p bbq_t1 15.0185f
C610 ri_n lna_vcm 3.33651f
C611 bbq_vbt bbq_t1 0.00159f
C612 q_q VDD 1.58462f
C613 q_q lq_cq 1.44037f
C614 li_mRpLb li_gln 0.60267f
C615 lo_bi_b lo_bi_Ngs 0.00888f
C616 nb enb 48.1835f
C617 bbq_o1p oq_n 0.00139f
C618 lo_bi_t VDD 0.5349f
C619 lo_bq_x lsq 1.38153f
C620 lq_lp lq_gcp 2.0507f
C621 inn nb 0.84533f
C622 lo_lq_lo1 lo_lq_D1y 0
C623 bbq_g3p oq_n 3.04668f
C624 nb lna_vt 0.12457f
C625 ls lo_bi_tb 0.03717f
C626 nb li_ln 0.42806f
C627 lo_bi_Py1 bq_n 0
C628 lo_bq_g0s en 0.00471f
C629 lo_lq_vq lo_lq_lo1 0.28227f
C630 ri_n ri_p 6.62475f
C631 bq_n bi_p 0
C632 bbq_mRp2b VDD 1.27896f
C633 nb bbq_o2n 0.53721f
C634 lo_bq_Pgs en 0.00905f
C635 nb lo_bi_Py2 0
C636 VDD lq_gcp 1.65299f
C637 lo_bq_b lsq 1.6034f
C638 bbi_o1p bbi_vb 0.14015f
C639 VDD bbq_t1 0.46847f
C640 b_nr b_vh 0.04885f
C641 nb rq_p 0.49764f
C642 lo_lq_D1x lo_lq_lo2 0.08987f
C643 nb li_vbt 0.12882f
C644 lo_bq_g0s VDD 0
C645 lo_bq_Ny2 ri_p 0
C646 li_mRpCb li_mRpCa 0.76885f
C647 lo_lq_lf aq 0.00489f
C648 lo_bq_Pgs VDD 0
C649 li_cx li_co 0.28525f
C650 en lo_bq_Py1 0.12284f
C651 lo_bq_t lo_bq_ta 1.27093f
C652 en lo_bi_tb 0.06062f
C653 lo_bi_x lo_bi_b 0.06191f
C654 lo_bq_Py2 lo_q 3.02187f
C655 q_i li_gcp 0.05927f
C656 lo_bi_x lo_bi_t 1.7784f
C657 bbi_vgr bbi_vb 8.98949f
C658 lq_vbt lq_gcp 0.00317f
C659 bbi_g2n bbi_vb 0.51815f
C660 lq_co lq_cb 0
C661 oi_p bbi_vb 1.61419f
C662 lo_bi_Ny0 en 0.81999f
C663 inp VDD 0.43429f
C664 oq_n bq_n 0.01688f
C665 lo_bq_Py1 VDD 0.56507f
C666 VDD lo_bi_tb 1.55495f
C667 lna_tail lna_outp 24.5656f
C668 nb bbi_g2p 0.07889f
C669 lo_lq_D1x VDD 0
C670 en lo_bq_Ny1 0.00107f
C671 bi_n bbi_o1n 0.54853f
C672 lq_co lq_ca 0.34422f
C673 lq_ct enb 0.05233f
C674 en b_vh 0.00139f
C675 li_vb li_vgr 9.55397f
C676 li_lp li_vgr 0.12743f
C677 lo_bi_Ny0 VDD 0.36895f
C678 lo_bq_a lsq 0.15892f
C679 rq_n lna_outn 0.20838f
C680 oi_n bbi_mRp3a 0.00909f
C681 lo_bi_Ny0 lo_bi_Ngs 0.07147f
C682 li_tL li_ln 0.51422f
C683 bq_n lsq 0.0525f
C684 lob_i ri_n 1.05507f
C685 lo_bq_Ny1 VDD 0.58962f
C686 ls lo_bi_Py0 0.0923f
C687 b_vh VDD 1.31067f
C688 bbq_o1n enb 0.32203f
C689 nb li_gcp 0.94136f
C690 li_mRpLb li_mRpLa 0.08841f
C691 bbi_mRp2b bbi_vb 0.57255f
C692 lo_lq_lo1 a_48450_713# 0
C693 en b_nr 0.08089f
C694 ls bq_p 0.04785f
C695 li_vgr li_gln 2.26794f
C696 lo_lq_D1y lsq 1.40306f
C697 bq_p lo_bi_Py0 0
C698 lq_gcn lq_cb 1.53463f
C699 lq_lp lq_vgr 0.12743f
C700 VDD lna_outn 0.98822f
C701 bbq_o1n bbq_o2n 0.38655f
C702 ls en 5.26976f
C703 lo_bi_x lo_bi_tb 0.17958f
C704 li_vb li_lp 0.23236f
C705 lo_lq_vq lsq 2.05308f
C706 lna_vcm lna_x2i_tail 0.00759f
C707 bbq_o1p enb 0.20141f
C708 lo_bi_ta lo_bi_b 0.06137f
C709 bbq_g3n bbq_o2n 6.81759f
C710 bbi_o1n bi_p 9.18763f
C711 b_nr VDD 0.56081f
C712 lob_i lo_bi_Ny2 4.35651f
C713 en lo_bi_Py0 0.73089f
C714 q_q lq_mRpCa 0.062f
C715 lq_gcn lq_ca 3.24031f
C716 bbq_o2p bbq_g2p 2.6676f
C717 bq_p bbq_vbt 0.00152f
C718 ri_n enb 0.07869f
C719 rq_n bq_p 3.75152f
C720 lob_q lo_bq_ta 0.02078f
C721 bbi_g3p bbi_vb 0.83647f
C722 lo_bi_Ny1 lo_bi_b 0.00411f
C723 lo_bi_ta lo_bi_t 1.27093f
C724 VDD lq_vgr 1.93315f
C725 inn ri_n 0
C726 bbq_g2n bbq_g2p 4.72021f
C727 en bq_p 4.62352f
C728 bbq_o1p bbq_o2n 0.0821f
C729 lq_ln lq_gcp 2.31969f
C730 ls VDD 0.35761f
C731 lna_x2i_tail ri_p 4.02866f
C732 lo_bi_Py1 bi_n 0
C733 bi_n bi_p 24.878f
C734 VDD bbi_o2p 2.48834f
C735 en lo_bq_tb 0.06062f
C736 bbq_g3p bbq_o2n 0.12772f
C737 oi_n li_vgr 0
C738 VDD lo_bi_Py0 0.35449f
C739 lq_mRpCa lq_gcp 0.45829f
C740 li_lp li_gln 4.11236f
C741 li_vb li_gln 2.65772f
C742 enb li_ct 0.05233f
C743 lo_bq_Py0 lo_bq_Pgs 0.07271f
C744 lo_lq_lo2 VDD 0
C745 oi_n bbi_o1n 0.00225f
C746 bq_p VDD 1.47274f
C747 lo_bi_Ny2 enb 0
C748 lq_glp lq_gcp 0
C749 bbi_g3n bbi_vb 0.60573f
C750 lo_bq_g0s lo_bq_t 0
C751 bbq_vbt VDD 1.66897f
C752 li_ct li_ln 0.12331f
C753 rq_n VDD 4.53069f
C754 nb bbq_o2p 0.04002f
C755 lq_vbt lq_vgr 0.76002f
C756 VDD lo_bq_tb 1.55527f
C757 bbq_mRp3a bbq_o2p 0.03426f
C758 oq_p bbq_vb 1.61419f
C759 lq_tL lq_gln 0.66214f
C760 bbi_t3 bbi_vb 0.14106f
C761 en VDD 4.00146f
C762 nb bbq_g2n 0.07879f
C763 oi_n bi_n 0.01688f
C764 li_vgr li_mRpCa 0.15699f
C765 lo_bq_Py2 lsq 0.6764f
C766 VDD lq_lp 1.6706f
C767 en lo_bi_Ngs 0.00905f
C768 a_47706_713# lo_lq_D1y 0.01134f
C769 lo_bq_Py0 lo_bq_Py1 1.276f
C770 VDD bbq_mRp3b 0.14807f
C771 enb bq_n 0.32081f
C772 bbi_t2 bbi_o2p 0.3005f
C773 lq_mRpLb lq_vgr 1.38037f
C774 lq_mRpLa lq_vgr 0.15699f
C775 inp lna_outp 0.58906f
C776 lo_bi_b lo_bi_a 2.81922f
C777 lo_lq_vq a_47706_713# 0.00198f
C778 oi_n li_lp 0.18927f
C779 bbi_vbt VDD 1.66897f
C780 bbi_o2n bbi_o1n 0.38655f
C781 oq_n bbq_vb 0.33016f
C782 lo_bi_x ls 1.38153f
C783 lq_cq VDD 0.3678f
C784 lo_bi_Py1 bi_p 0
C785 lo_bi_t lo_bi_a 0.00509f
C786 bbq_t2 bbq_g2p 2.90297f
C787 bbq_o2n bq_n 0.99043f
C788 bi_n ri_p 1.5904f
C789 VDD lo_bi_Ngs 0.00217f
C790 q_q lq_vb 0.24451f
C791 bq_n lo_bi_Py2 0.00133f
C792 lna_tail nb 18.5174f
C793 oq_p lq_gln 0.30002f
C794 bbq_vgr bbq_g2p 0.18549f
C795 a_48450_713# lsq 0.01348f
C796 li_mRpLa li_vgr 0.15699f
C797 lq_vbt lq_lp 0.14942f
C798 bi_n bbi_o2n 0.99043f
C799 oq_p lq_tL 0.00244f
C800 lo_lq_vq lo_lq_tt 0.16377f
C801 bbi_o1p bbi_o2p 0.17851f
C802 rq_p bq_n 1.5904f
C803 lo_bi_b lo_i 0.13724f
C804 li_vb li_mRpCa 0.98733f
C805 lo_bi_Ny1 lo_bi_Ny0 1.27426f
C806 lo_q lsq 0.09369f
C807 oi_n li_gln 2.16225f
C808 nb bbi_vb 2.5559f
C809 lo_bi_t lo_i 0.28918f
C810 li_cb VDD 1.08916f
C811 bbi_o1n bbi_t1 10.899f
C812 lo_bi_x en 0.54597f
C813 lq_vb lq_gcp 0.47644f
C814 lq_cb enb 0.00333f
C815 oq_n lq_gln 2.16225f
C816 lo_lq_lg lo_lq_vq 0.33992f
C817 lq_vbt VDD 0.67806f
C818 oi_n bi_p 0.01544f
C819 bbi_mRp2a bbi_g2p 2.71538f
C820 oq_n lq_tL 0.77929f
C821 lq_gcn lq_gln 0
C822 bbq_t2 nb 2.83595f
C823 lq_ca enb 0.00985f
C824 bbq_mRp2b bbq_g2p 0.62517f
C825 lo_lq_lo1 lsq 0.12133f
C826 lna_outp lna_outn 3.56533f
C827 bbi_vgr bbi_o2p 0.23215f
C828 li_mRpCb li_gcp 0.14475f
C829 bbi_g2n bbi_o2p 4.3121f
C830 bbi_mRp3b bbi_mRp3a 0.08704f
C831 bi_n bbi_t1 15.1293f
C832 bbq_vgr nb 2.2874f
C833 oi_p bbi_o2p 0.29088f
C834 lq_mRpLb VDD 0.03387f
C835 VDD lq_mRpLa 0.21658f
C836 bbq_vgr bbq_mRp3a 0.05207f
C837 lo_bi_x VDD 0.38366f
C838 lo_bq_g0s lob_q 0.00261f
C839 lq_co lq_gcn 0.00689f
C840 bbq_g2p bbq_t1 0.01205f
C841 lq_ln lq_vgr 2.69553f
C842 li_gcp li_ct 0.95309f
C843 lna_x2q_tail lna_vcm 0.00345f
C844 bi_p ri_p 2.29294f
C845 li_mRpLa li_vb 1.00198f
C846 inn lna_x2i_tail 0
C847 bbi_vbt bbi_o1p 1.6832f
C848 lq_mRpCb lq_gcn 0.54081f
C849 nb q_q 0.11424f
C850 lq_vgr lq_mRpCa 0.15699f
C851 bbi_o1p VDD 1.62549f
C852 lo_bi_t nb 0
C853 bbq_o1n bbq_o2p 0.37415f
C854 bbi_o2n bi_p 1.03194f
C855 oq_p oq_n 11.9991f
C856 lo_bi_b lo_bi_g0s 0
C857 lo_bi_ta ls 0.29598f
C858 lq_glp lq_vgr 0.11821f
C859 bbq_o1n bbq_g2n 6.65711f
C860 bbq_t3 nb 2.98191f
C861 bbq_g3n bbq_o2p 0.19553f
C862 lo_bq_x lo_bq_ta 0
C863 lob_i bi_n 1.99701f
C864 lo_bi_t lo_bi_g0s 0
C865 lq_vbt lq_mRpLa 0.07167f
C866 nb lq_gcp 0.94136f
C867 li_mRpLa li_gln 0.14083f
C868 bbi_mRp2b bbi_o2p 0.58102f
C869 lna_vcm ri_p 0.05223f
C870 bbi_vgr bbi_vbt 0.08774f
C871 lo_bi_tb lo_i 0.00378f
C872 bbq_o1p bbq_o2p 0.17851f
C873 rq_n lna_outp 4.85285f
C874 lo_bq_Py0 en 0.73089f
C875 bbi_vgr VDD 8.70759f
C876 bbi_g2n VDD 1.86961f
C877 nb bbq_t1 0.70522f
C878 bbi_o1n enb 0.32203f
C879 lo_bq_t lo_bq_tb 1.34876f
C880 li_vgr li_ln 2.69553f
C881 lq_ln lq_lp 0.86658f
C882 oi_p VDD 1.70229f
C883 bbq_o1p bbq_g2n 0.02964f
C884 oi_n bbi_o2n 1.58613f
C885 bbq_g3p bbq_o2p 5.93947f
C886 lo_bq_b lo_bq_ta 0.06137f
C887 lo_bq_t en 1.04581f
C888 bbi_t1 bi_p 15.0185f
C889 lq_mRpLb lq_mRpLa 0.08841f
C890 VDD li_ca 0.90676f
C891 lo_lq_D1qb lo_lq_D1y 0.74379f
C892 lo_bi_ta en 0.07312f
C893 bbq_g3p bbq_g2n 0.00924f
C894 lob_q lo_bq_Ny1 0.20682f
C895 bi_n enb 0.45995f
C896 lo_bi_Ny1 en 0.00102f
C897 lo_lq_lf lo_lq_D1y 0
C898 q_q lq_cx 0.00495f
C899 lo_bq_Py0 VDD 0.35459f
C900 lo_lq_D1qb lo_lq_vq 0.59062f
C901 VDD lq_ln 1.63445f
C902 li_vbt li_vgr 0.76002f
C903 lq_glp lq_lp 0.74628f
C904 bbi_g3p bbi_o2p 5.93947f
C905 b_n2 b_vh 2.80573f
C906 lna_outp VDD 5.31192f
C907 lo_bq_t VDD 0.53509f
C908 lo_lq_lf lo_lq_vq 3.23667f
C909 VDD lq_mRpCa 0.16896f
C910 li_gcn VDD 1.69492f
C911 lo_bi_ta VDD 0.33628f
C912 inp nb 0.23145f
C913 li_lp enb 0.05f
C914 bi_n lo_bi_Py2 0
C915 lob_i bi_p 1.29033f
C916 bbi_g2n bbi_t2 2.93218f
C917 li_cb li_ca 1.75008f
C918 bbi_vgr bbi_t2 0
C919 oi_n bbi_t1 0.00386f
C920 bbq_o2n bbq_vb 0.35264f
C921 lo_bq_Ngs en 0.00905f
C922 oi_p bbi_t2 0.47994f
C923 lq_glp VDD 1.20118f
C924 lo_bi_Ny1 VDD 0.58954f
C925 lo_bi_a ls 0.15892f
C926 lq_cx lq_gcp 0
C927 VDD bbi_mRp2b 1.27896f
C928 lq_vb lq_vgr 9.55397f
C929 li_lp li_ln 0.86658f
C930 li_vb li_ln 0.22387f
C931 lo_bi_a lo_bi_Py0 1.46313f
C932 bbq_vgr bbq_o1n 2.7789f
C933 bbq_g3n bbq_t2 0
C934 lo_bi_Ny0 nb 0
C935 rq_p lo_q 1.12024f
C936 VDD li_glp 1.20118f
C937 bbi_g3n bbi_o2p 0.19553f
C938 lq_vbt lq_ln 0.88479f
C939 li_gcp li_cx 0
C940 lo_lq_lg lo_lq_lo1 0.20859f
C941 enb lq_gln 0.01156f
C942 b_n2 b_nr 1.21756f
C943 bq_n bbq_o2p 1.11728f
C944 bbq_vgr bbq_g3n 0.06347f
C945 lo_bq_Ngs VDD 0.00217f
C946 lo_bq_a lo_bq_ta 1.27941f
C947 bbq_g2n bq_n 0.02783f
C948 li_cb li_gcn 1.53463f
C949 bbi_vgr bbi_o1p 0.31673f
C950 bbi_o1n bbi_g2p 2.57561f
C951 bbi_t3 bbi_o2p 0
C952 li_lp li_vbt 0.14942f
C953 lq_ct lq_gcp 0.95309f
C954 li_vb li_vbt 0.94378f
C955 bbi_g2n bbi_o1p 0.02964f
C956 enb li_gln 0.01156f
C957 nb b_vh 0.784f
C958 lo_lq_q1 lo_lq_D1y 0.00721f
C959 enb bi_p 0.84143f
C960 ls lo_i 0.09108f
C961 VDD bbi_g3p 4.33045f
C962 bbq_vgr bbq_o1p 0.31673f
C963 bbi_o2n bbi_t1 0.48555f
C964 lq_mRpLa lq_ln 0.05545f
C965 lq_glp lq_vbt 0.87545f
C966 bbq_g3p bbq_t2 0.01189f
C967 lo_bi_a en 1.31385f
C968 li_ln li_gln 0.99875f
C969 bbq_mRp2a bbq_o2p 0.02666f
C970 lob_q bq_p 1.24465f
C971 lo_bi_Py0 lo_i 0.53184f
C972 bbq_vgr bbq_g3p 0.17684f
C973 lo_lq_q1 lo_lq_vq 0.21914f
C974 bi_n bbi_g2p 0.02671f
C975 bbq_mRp2a bbq_g2n 0.13427f
C976 lob_q rq_n 1.05507f
C977 bbq_g3n bbq_t3 2.927f
C978 lo_bi_ta lo_bi_x 0
C979 nb lna_outn 4.11094f
C980 lq_lp lq_vb 0.23236f
C981 li_gcp li_vgr 3.10457f
C982 lob_q lo_bq_tb 0.48724f
C983 lo_bi_Py1 lo_bi_Py2 2.44938f
C984 bq_p bbq_g2p 0.01844f
C985 lo_bi_Py2 bi_p 0
C986 bq_p lo_i 0.01838f
C987 lob_i ri_p 1.13241f
C988 lq_mRpLb lq_glp 0.10842f
C989 lob_q en 0.08077f
C990 bbq_vbt bbq_g2p 1.35765f
C991 lq_glp lq_mRpLa 2.72864f
C992 VDD aq 0
C993 oq_p enb 0.13239f
C994 bbi_mRp2a bbi_vb 3.04322f
C995 bbi_vgr bbi_g2n 1.6135f
C996 nb b_nr 2.47068f
C997 lo_bi_a VDD 0.76132f
C998 bbi_vgr oi_p 0.90342f
C999 bbq_o1n bbq_t1 10.899f
C1000 li_vbt li_gln 0.37516f
C1001 bbi_g2n oi_p 0.06647f
C1002 lo_bq_g0s lo_bq_x 0.03739f
C1003 b_n2 en 0.18292f
C1004 nb lq_vgr 0.35015f
C1005 bbi_g3n VDD 3.79046f
C1006 en lo_i 0.47012f
C1007 oi_n enb 0.6238f
C1008 VDD lq_vb 5.48011f
C1009 lq_cq lq_vb 0.00355f
C1010 lna_vcm enb 2.73623f
C1011 lo_lq_D1qb a_48450_713# 0.0061f
C1012 bbq_t3 bbq_g3p 2.91775f
C1013 oq_p bbq_o2n 2.54324f
C1014 inn lna_vcm 3.43594f
C1015 bbi_t2 bbi_g3p 0.01189f
C1016 lob_q VDD 1.73717f
C1017 nb bbi_o2p 0.04002f
C1018 lna_vt lna_vcm 0.07779f
C1019 oi_n li_ln 0.93324f
C1020 oq_n enb 0.15529f
C1021 nb lo_bi_Py0 0
C1022 bbq_o1p bbq_t1 10.4824f
C1023 q_i VDD 1.58452f
C1024 b_n2 VDD 1.60615f
C1025 lo_bq_g0s lo_bq_b 0
C1026 lna_x2q_tail rq_p 4.09819f
C1027 a_47706_713# lsq 0.01386f
C1028 lo_bi_g0s ls 0.00494f
C1029 VDD bbq_g2p 2.40668f
C1030 VDD lo_i 2.35959f
C1031 enb ri_p 0.05585f
C1032 lq_gcn enb 0.00488f
C1033 a_48024_1776# lo_lq_D1y 0.00509f
C1034 nb bq_p 0.11175f
C1035 li_vb li_gcp 0.47644f
C1036 li_lp li_gcp 2.0507f
C1037 oq_n bbq_o2n 1.58613f
C1038 rq_n nb 3.87899f
C1039 li_gcn li_ca 3.24031f
C1040 bbi_g2p bi_p 0.01844f
C1041 lo_bq_Ny0 lo_bq_Ny1 1.27426f
C1042 lna_vcm rq_p 0.24483f
C1043 lo_lq_vq a_48024_1776# 0.23085f
C1044 bbi_o2n enb 0.78638f
C1045 bbi_vgr bbi_mRp2b 0.00978f
C1046 b_x enb 0.45325f
C1047 lq_vbt lq_vb 0.94378f
C1048 bbi_g2n bbi_mRp2b 0.62129f
C1049 lo_lq_D1qb lo_lq_lo1 0
C1050 bbi_g3n bbi_t2 0
C1051 nb en 0.67458f
C1052 lo_lq_tt lsq 0.83329f
C1053 nb lq_lp 0.15624f
C1054 lo_lq_lf lo_lq_lo1 0.00642f
C1055 q_i li_cb 0
C1056 bbi_mRp3a bbi_vb 0.68743f
C1057 lo_bq_Py1 lo_bq_b 0
C1058 lo_bi_x lo_bi_a 0
C1059 oi_p li_glp 2.16317f
C1060 lo_bi_g0s en 0.00471f
C1061 bbi_t3 bbi_t2 0.00372f
C1062 bbq_mRp3a bbq_mRp3b 0.08704f
C1063 bbq_vgr bbq_mRp2a 0.05312f
C1064 lq_mRpLb lq_vb 0.73361f
C1065 lo_lq_lg lsq 0
C1066 lq_glp lq_ln 2.62696f
C1067 lq_mRpLa lq_vb 1.00198f
C1068 li_gcp li_gln 0
C1069 nb VDD 11.5727f
C1070 bbq_mRp3a VDD 0.1197f
C1071 oi_n bbi_g2p 0.23654f
C1072 bbi_g2n bbi_g3p 0.00924f
C1073 bbi_vgr bbi_g3p 0.17684f
C1074 oi_p bbi_g3p 1.08101f
C1075 bbi_t1 enb 0.21873f
C1076 lo_bi_g0s VDD 0
C1077 li_mRpLa li_ln 0.05545f
C1078 lo_bq_Ny1 lo_bq_b 0.00411f
C1079 lo_bi_x lo_i 0.06208f
C1080 bq_n bbq_t1 15.1293f
C1081 lo_bq_a lo_bq_Pgs 0.00896f
C1082 bbq_vb bbq_o2p 1.28735f
C1083 bbq_mRp2a bbq_mRp2b 0.14576f
C1084 lq_cb q_q 0
C1085 nb li_cb 0.10392f
C1086 bbq_g2n bbq_vb 0.51815f
C1087 bbi_vgr bbi_g3n 0.06347f
C1088 nb lq_vbt 0.12882f
C1089 li_mRpLa li_vbt 0.07167f
C1090 lo_q lo_bq_ta 0.10101f
C1091 bbi_g3n oi_p 3.27704f
C1092 nb bbi_t2 2.83595f
C1093 bbi_o2n bbi_g2p 3.24838f
C1094 lq_ca q_q 0.0045f
C1095 lo_bq_a lo_bq_Py1 0
C1096 lo_bq_Ny1 lo_bq_Ny2 2.32672f
C1097 lo_bq_Ny0 lo_bq_tb 0.06857f
C1098 lo_bi_Ny0 lo_bi_Ny2 0.00506f
C1099 ri_n lna_outn 0.34015f
C1100 bbi_t3 oi_p 0.49853f
C1101 VDD lq_cx 0.26162f
C1102 nb lq_mRpLa 0.13287f
C1103 lq_cq lq_cx 0
C1104 lq_mRpLb nb 0.09398f
C1105 lo_bq_Ny0 en 0.81999f
C1106 lq_cb lq_gcp 0.40553f
C1107 lq_ct lq_lp 0.00147f
C1108 bbi_o1n bbi_vb 0.18862f
C1109 q_i li_ca 0.0045f
C1110 lq_ln lq_vb 0.22387f
C1111 lo_bi_ta lo_bi_a 1.27941f
C1112 bbq_o1n bq_p 9.18763f
C1113 lo_bi_x lo_bi_g0s 0.03739f
C1114 bbq_o1n bbq_vbt 1.19688f
C1115 nb bbi_o1p 0
C1116 lq_ca lq_gcp 1.11631f
C1117 li_gcp li_mRpCa 0.45829f
C1118 lo_bq_x lo_bq_tb 0.17958f
C1119 lq_vb lq_mRpCa 0.98733f
C1120 en lo_bq_x 0.54597f
C1121 lo_bq_Ny0 VDD 0.36906f
C1122 bbi_t1 bbi_g2p 0.01205f
C1123 lo_bq_t lob_q 0.09542f
C1124 li_tL VDD 0.15562f
C1125 lo_lq_D1x lo_lq_D1y 0.88042f
C1126 lq_glp lq_vb 3.18848f
C1127 lo_lq_D1qb lsq 1.76399f
C1128 lna_vt enb 0.39792f
C1129 li_cq VDD 0.3678f
C1130 q_i li_gcn 0.0493f
C1131 enb li_ln 0.10666f
C1132 bbq_o1p bq_p 0.43338f
C1133 lo_lq_D1x lo_lq_vq 0.26831f
C1134 lo_lq_lf lsq 0.33461f
C1135 bbq_o1p bbq_vbt 1.6832f
C1136 lo_bq_b lo_bq_tb 0.80645f
C1137 bbq_o2n enb 0.78638f
C1138 lo_bi_ta lo_i 0.10101f
C1139 en lo_bq_b 2.94909f
C1140 bbq_g3n bbq_mRp3b 0.50302f
C1141 lo_bq_x VDD 0.38375f
C1142 bbi_vgr nb 2.29375f
C1143 ls lo_bi_Pgs 0.00248f
C1144 nb bbi_g2n 0.07879f
C1145 oq_p bbq_o2p 0.29088f
C1146 bbq_o1n VDD 1.62614f
C1147 nb oi_p 1.97217f
C1148 bbq_vgr bbq_vb 8.98949f
C1149 lo_bi_Pgs lo_bi_Py0 0.07271f
C1150 oq_p bbq_g2n 0.06647f
C1151 en ri_n 0.60495f
C1152 nb li_ca 0.15947f
C1153 enb rq_p 7.78755f
C1154 enb li_vbt 0.99337f
C1155 bbq_g3n VDD 3.79046f
C1156 lo_bi_b bi_n 0
C1157 bbi_g3n bbi_g3p 0.34872f
C1158 lob_q lo_bq_Ngs 0.00392f
C1159 lna_vt rq_p 0.0591f
C1160 li_cq li_cb 0
C1161 bbi_mRp2a bbi_o2p 0.02666f
C1162 bbq_g3p bbq_mRp3b 0.14588f
C1163 VDD lo_bq_b 1.52233f
C1164 lo_bi_t bi_n 0
C1165 nb lq_ln 0.42806f
C1166 li_vbt li_ln 0.88479f
C1167 aq VSS 4.5261f
C1168 inn VSS 7.74055f
C1169 inp VSS 8.6135f
C1170 ls VSS 6.44886f
C1171 en VSS 26.6322f
C1172 q_q VSS 4.33525f
C1173 q_i VSS 4.33535f
C1174 VDD VSS 1.17987p
C1175 a_48450_713# VSS 0.14599f
C1176 a_47706_713# VSS 0.14869f
C1177 lo_lq_lg VSS 1.43421f
C1178 lo_lq_lo1 VSS 0.65273f
C1179 lo_lq_D1x VSS 0.56779f
C1180 a_48024_1776# VSS 0.01195f
C1181 lo_lq_tt VSS 0.3924f
C1182 lo_lq_q1 VSS 0.35733f
C1183 lo_lq_D1y VSS 0.53224f
C1184 lo_lq_D1qb VSS 1.02163f
C1185 lo_lq_lo2 VSS 0.69056f
C1186 lna_x2q_tail VSS 6.46619f
C1187 lna_vt VSS 0.67237f
C1188 lo_lq_lf VSS 7.527f
C1189 rq_n VSS 9.89192f
C1190 rq_p VSS 9.44928f
C1191 lna_tail VSS 23.7494f
C1192 lo_bq_Pgs VSS 0.10589f
C1193 lo_bq_g0s VSS 0.06752f
C1194 lo_bq_Ngs VSS 0.10696f
C1195 lo_q VSS 3.28457f
C1196 lo_bq_Py0 VSS 0.79732f
C1197 lo_bq_a VSS 1.53489f
C1198 lsq VSS 9.52141f
C1199 lo_bq_x VSS 0.76481f
C1200 lo_bq_Py1 VSS 1.17572f
C1201 lo_bq_ta VSS 0.8476f
C1202 lo_bq_b VSS 2.08198f
C1203 lo_bq_Ny0 VSS 0.84813f
C1204 lo_bq_tb VSS 1.17359f
C1205 lo_bq_Ny1 VSS 1.1181f
C1206 lo_bq_t VSS 1.2788f
C1207 lna_vcm VSS 24.5691f
C1208 lna_x2i_tail VSS 6.56898f
C1209 lna_outn VSS 11.3951f
C1210 lna_outp VSS 12.3584f
C1211 lob_q VSS 3.87574f
C1212 lo_bq_Py2 VSS 1.6314f
C1213 lo_bq_Ny2 VSS 1.67776f
C1214 ri_n VSS 9.25097f
C1215 b_vh VSS 1.07541f
C1216 ri_p VSS 10.1904f
C1217 lo_bi_Pgs VSS 0.10589f
C1218 lo_bi_g0s VSS 0.06752f
C1219 lo_bi_Ngs VSS 0.10696f
C1220 b_nr VSS 1.4407f
C1221 b_n2 VSS 2.66748f
C1222 b_x VSS 1.85733f
C1223 lo_i VSS 3.28558f
C1224 lo_bi_Py0 VSS 0.79737f
C1225 lo_bi_a VSS 1.535f
C1226 lo_bi_x VSS 0.76485f
C1227 lo_bi_Py1 VSS 1.17574f
C1228 lo_bi_ta VSS 0.84765f
C1229 lo_bi_b VSS 2.08208f
C1230 lo_bi_Ny0 VSS 0.84818f
C1231 lo_bi_tb VSS 1.17359f
C1232 lo_bi_Ny1 VSS 1.11812f
C1233 lo_bi_t VSS 1.27885f
C1234 lob_i VSS 3.87676f
C1235 lo_bi_Py2 VSS 1.62624f
C1236 lo_bi_Ny2 VSS 1.67769f
C1237 bbq_t3 VSS 2.88763f
C1238 bbq_t2 VSS 2.48721f
C1239 bbq_t1 VSS 4.88036f
C1240 bq_n VSS 24.8208f
C1241 bbi_t3 VSS 2.88763f
C1242 bbi_t2 VSS 2.48721f
C1243 bq_p VSS 22.1666f
C1244 bbi_t1 VSS 4.88036f
C1245 bi_n VSS 27.4935f
C1246 bi_p VSS 28.586f
C1247 bbq_mRp3b VSS 0.70445f
C1248 bbq_mRp3a VSS 0.87833f
C1249 bbq_mRp2b VSS 0.92869f
C1250 bbq_mRp2a VSS 0.74262f
C1251 bbq_vgr VSS 14.9963f
C1252 bbi_mRp3b VSS 0.70445f
C1253 bbi_mRp3a VSS 0.87833f
C1254 bbi_mRp2b VSS 0.92869f
C1255 bbi_mRp2a VSS 0.74262f
C1256 bbi_vgr VSS 15.0005f
C1257 bbq_vbt VSS 1.69129f
C1258 bbi_vbt VSS 1.69129f
C1259 lq_ct VSS 0.51595f
C1260 lq_tL VSS 0.58536f
C1261 li_ct VSS 0.51595f
C1262 li_tL VSS 0.58536f
C1263 lq_co VSS 0.91906f
C1264 lq_cx VSS 1.19827f
C1265 lq_ca VSS 2.01286f
C1266 lq_cb VSS 1.40895f
C1267 lq_cq VSS 0.83872f
C1268 li_co VSS 0.91919f
C1269 li_cx VSS 1.19827f
C1270 li_ca VSS 2.01279f
C1271 li_cb VSS 1.40882f
C1272 li_cq VSS 0.83872f
C1273 enb VSS 46.9225f
C1274 lq_mRpCb VSS 0.7771f
C1275 lq_mRpCa VSS 0.84957f
C1276 lq_mRpLb VSS 1.72501f
C1277 lq_mRpLa VSS 0.89621f
C1278 li_mRpCb VSS 0.7771f
C1279 li_mRpCa VSS 0.84957f
C1280 li_mRpLb VSS 1.72501f
C1281 li_mRpLa VSS 0.89621f
C1282 lq_vgr VSS 8.62119f
C1283 lq_vbt VSS 1.12351f
C1284 li_vgr VSS 8.6227f
C1285 nb VSS 0.15772p
C1286 li_vbt VSS 1.12351f
C1287 lo_lq_vq VSS 45.6631f
C1288 bbq_o2n VSS 68.2533f
C1289 bbq_o2p VSS 65.827f
C1290 bbq_o1n VSS 48.1919f
C1291 bbq_o1p VSS 42.8538f
C1292 bbi_o2n VSS 68.2533f
C1293 bbi_o2p VSS 65.827f
C1294 bbi_o1n VSS 48.1919f
C1295 bbi_o1p VSS 42.8538f
C1296 bbq_g3n VSS 8.5093f
C1297 bbq_g3p VSS 7.11958f
C1298 bbq_g2n VSS 8.075f
C1299 bbq_g2p VSS 8.10695f
C1300 bbq_vb VSS 63.1562f
C1301 bbi_g3n VSS 8.5093f
C1302 bbi_g3p VSS 7.11958f
C1303 bbi_g2n VSS 8.075f
C1304 bbi_g2p VSS 8.10695f
C1305 bbi_vb VSS 63.1562f
C1306 lq_ln VSS 26.3767f
C1307 lq_lp VSS 23.7524f
C1308 oq_p VSS 56.8282f
C1309 oq_n VSS 54.2393f
C1310 li_ln VSS 26.3767f
C1311 li_lp VSS 23.7524f
C1312 oi_p VSS 55.6623f
C1313 oi_n VSS 53.5558f
C1314 lq_gcn VSS 5.0031f
C1315 lq_gcp VSS 6.82863f
C1316 lq_gln VSS 4.45907f
C1317 lq_glp VSS 4.34318f
C1318 lq_vb VSS 66.65579f
C1319 li_gcn VSS 5.00307f
C1320 li_gcp VSS 6.82732f
C1321 li_gln VSS 4.45907f
C1322 li_glp VSS 4.34318f
C1323 li_vb VSS 66.65579f
.ends
