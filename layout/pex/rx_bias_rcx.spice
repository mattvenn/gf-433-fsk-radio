* rx_bias: magic R+C extraction of layout/rx_bias.gds (layout/gen/pex.sh)
* rcfix.py: split-net C to VSS scaled by (S - K) / S on 4 nets (coupling double count removed)
* extracted 2026-11-15T23:47:43+01:00 with magic 8.3.642, mode rc, from rx_bias.gds
.subckt rx_bias VDD VSS en enb nb
X0 VSS.t8 nr VSS.t7 ppolyf_u r_width=2u r_length=29.72u
X1 x nb.t13 VSS.t10 VSS.t9 nfet_03v3 ad=2p pd=6u as=2p ps=6u w=2u l=0.28u
X2 nb.t1 x n2 VSS.t6 nfet_03v3 ad=1p pd=4u as=1p ps=4u w=1u l=0.28u
X3 VSS.t13 nb.t11 VSS.t13 VSS.t11 nfet_03v3 ad=4.095p pd=9.19u as=0 ps=0 w=8.19u l=10u
X4 enb.t1 en.t1 VDD.t3 VDD.t2 pfet_03v3 ad=1p pd=4u as=0.45p ps=2.9u w=1u l=0.28u
X5 n2 n2 vh VDD.t6 pfet_03v3 ad=2p pd=5u as=2p ps=5u w=4u l=1u
X6 vh n2 n2 VDD.t7 pfet_03v3 ad=2p pd=5u as=2p ps=5u w=4u l=1u
X7 enb.t0 en.t0 VSS.t5 VSS.t4 nfet_03v3 ad=0.42p pd=2.84u as=0.189p ps=1.74u w=0.42u l=0.28u
X8 nb.t5 nb.t4 VSS.t16 VSS.t15 nfet_03v3 ad=2p pd=6u as=0.9p ps=4.9u w=2u l=0.5u
X9 nr nb.t7 n2 VSS.t19 nfet_03v3 ad=1p pd=3u as=2p ps=6u w=2u l=0.5u
X10 n2 nb.t6 nr VSS.t20 nfet_03v3 ad=2p pd=6u as=1p ps=3u w=2u l=0.5u
X11 vh enb.t4 VDD.t1 VDD.t0 pfet_03v3 ad=4p pd=10u as=1.8p ps=8.9u w=4u l=0.28u
X12 VSS.t14 nb.t10 VSS.t14 VSS.t11 nfet_03v3 ad=4.095p pd=9.19u as=0 ps=0 w=8.19u l=10u
X13 x enb.t2 VSS.t3 VSS.t2 nfet_03v3 ad=0.42p pd=2.84u as=0.189p ps=1.74u w=0.42u l=0.28u
X14 x VSS.t21 vh VDD.t4 pfet_03v3 ad=0.42p pd=2.84u as=0.42p ps=2.84u w=0.42u l=10u
X15 nb.t3 n2 vh VDD.t8 pfet_03v3 ad=4p pd=10u as=2p ps=5u w=4u l=1u
X16 nr nb.t9 n2 VSS.t17 nfet_03v3 ad=1p pd=3u as=2p ps=6u w=2u l=0.5u
X17 n2 nb.t8 nr VSS.t18 nfet_03v3 ad=2p pd=6u as=1p ps=3u w=2u l=0.5u
X18 VSS.t12 nb.t12 VSS.t12 VSS.t11 nfet_03v3 ad=8.19p pd=18.38u as=0 ps=0 w=8.19u l=10u
X19 vh n2 nb.t2 VDD.t5 pfet_03v3 ad=2p pd=5u as=4p ps=10u w=4u l=1u
X20 nb.t0 enb.t3 VSS.t1 VSS.t0 nfet_03v3 ad=0.42p pd=2.84u as=0.189p ps=1.74u w=0.42u l=0.28u
R0 en.n0 en.t1 32.4335
R1 en.n0 en.t0 24.1492
R2 en en.n0 11.7017
R3 enb.n1 enb.t4 71.3796
R4 enb.n3 enb.t2 28.8103
R5 enb.n1 enb.t3 24.3103
R6 enb.n0 enb.t0 14.3618
R7 enb.n0 enb.t1 7.13195
R8 enb enb.n3 6.12642
R9 enb.n2 enb.n0 4.94813
R10 enb.n2 enb.n1 4.5005
R11 enb.n3 enb.n2 0.552342
R12 nb.n2 nb.t13 49.6293
R13 nb.n8 nb.t9 34.1647
R14 nb.n7 nb.t8 34.1647
R15 nb.n4 nb.t6 34.1647
R16 nb.n5 nb.t7 29.6554
R17 nb.n9 nb.t4 29.6492
R18 nb.n10 nb.t0 20.001
R19 nb.n0 nb.t10 19.0488
R20 nb.n1 nb.t12 16.4435
R21 nb.n0 nb.t11 16.4435
R22 nb.n2 nb.t1 12.1837
R23 nb.n11 nb.t5 8.55997
R24 nb nb.n12 6.85116
R25 nb nb.n3 5.37089
R26 nb.n6 nb.n5 4.5005
R27 nb.n10 nb.n9 4.5005
R28 nb.n3 nb 4.08129
R29 nb.n4 nb 3.62182
R30 nb.n5 nb.t3 2.74178
R31 nb.n9 nb.t2 2.73564
R32 nb.n1 nb.n0 2.60576
R33 nb.n3 nb.n2 1.57313
R34 nb nb.n1 0.973921
R35 nb.n7 nb.n6 0.758395
R36 nb.n12 nb.n11 0.431553
R37 nb.n8 nb.n7 0.355763
R38 nb.n6 nb.n4 0.332079
R39 nb.n11 nb.n10 0.2255
R40 nb.n12 nb.n8 0.126026
R41 VDD.n14 VDD.t8 9877.39
R42 VDD.n13 VDD.t0 883.701
R43 VDD.t8 VDD.t7 284.495
R44 VDD.t0 VDD.t2 274.726
R45 VDD.t5 VDD.n13 231.279
R46 VDD.t6 VDD.t5 220.264
R47 VDD.t7 VDD.t6 206.327
R48 VDD.n13 VDD.t4 52.6426
R49 VDD.n47 VDD.t3 5.42655
R50 VDD.n45 VDD.t1 1.73004
R51 VDD.n30 VDD.n4 1.5755
R52 VDD VDD.n47 1.54681
R53 VDD.n44 VDD.n43 1.50144
R54 VDD.n31 VDD.n30 1.5005
R55 VDD.n29 VDD.n28 1.5005
R56 VDD.n8 VDD.n7 1.5005
R57 VDD.n23 VDD.n22 1.5005
R58 VDD.n21 VDD.n20 1.5005
R59 VDD.n12 VDD.n11 1.5005
R60 VDD.n17 VDD.n16 1.5005
R61 VDD.n19 VDD.n18 1.5005
R62 VDD.n10 VDD.n9 1.5005
R63 VDD.n25 VDD.n24 1.5005
R64 VDD.n27 VDD.n26 1.5005
R65 VDD.n6 VDD.n5 1.5005
R66 VDD.n33 VDD.n32 1.5005
R67 VDD.n35 VDD.n34 1.5005
R68 VDD.n36 VDD.n3 1.5005
R69 VDD.n38 VDD.n37 1.5005
R70 VDD.n39 VDD.n2 1.5005
R71 VDD.n41 VDD.n40 1.5005
R72 VDD.n42 VDD.n1 1.5005
R73 VDD.n46 VDD.n0 1.5005
R74 VDD.n15 VDD.n14 0.369582
R75 VDD.n15 VDD.n11 0.359614
R76 VDD.n16 VDD.n15 0.131884
R77 VDD.n18 VDD.n17 0.0755
R78 VDD.n18 VDD.n9 0.0755
R79 VDD.n25 VDD.n9 0.0755
R80 VDD.n26 VDD.n25 0.0755
R81 VDD.n26 VDD.n5 0.0755
R82 VDD.n33 VDD.n5 0.0755
R83 VDD.n34 VDD.n33 0.0755
R84 VDD.n34 VDD.n3 0.0755
R85 VDD.n38 VDD.n3 0.0755
R86 VDD.n39 VDD.n38 0.0755
R87 VDD.n40 VDD.n39 0.0755
R88 VDD.n40 VDD.n1 0.0755
R89 VDD.n44 VDD.n1 0.0755
R90 VDD.n21 VDD.n11 0.0755
R91 VDD.n22 VDD.n21 0.0755
R92 VDD.n22 VDD.n7 0.0755
R93 VDD.n29 VDD.n7 0.0755
R94 VDD.n30 VDD.n29 0.0755
R95 VDD.n36 VDD.n35 0.0755
R96 VDD.n37 VDD.n36 0.0755
R97 VDD.n37 VDD.n2 0.0755
R98 VDD.n41 VDD.n2 0.0755
R99 VDD.n42 VDD.n41 0.0755
R100 VDD.n43 VDD.n42 0.0752683
R101 VDD.n43 VDD.n0 0.0749024
R102 VDD.n16 VDD.n12 0.059
R103 VDD.n20 VDD.n19 0.059
R104 VDD.n23 VDD.n10 0.059
R105 VDD.n24 VDD.n8 0.059
R106 VDD.n28 VDD.n27 0.059
R107 VDD.n31 VDD.n6 0.059
R108 VDD.n32 VDD.n4 0.059
R109 VDD VDD.n0 0.054875
R110 VDD.n47 VDD.n46 0.0498125
R111 VDD.n46 VDD.n45 0.0460625
R112 VDD.n17 VDD.n14 0.03425
R113 VDD.n45 VDD.n44 0.0299375
R114 VDD.n19 VDD.n12 0.017
R115 VDD.n20 VDD.n10 0.017
R116 VDD.n24 VDD.n23 0.017
R117 VDD.n27 VDD.n8 0.017
R118 VDD.n28 VDD.n6 0.017
R119 VDD.n32 VDD.n31 0.017
R120 VDD.n35 VDD.n4 0.017
R121 VSS.t4 VSS.t6 114329
R122 VSS.t7 VSS.n176 31522.7
R123 VSS.t9 VSS.n27 1734.42
R124 VSS.t19 VSS.t18 960.898
R125 VSS.t17 VSS.t15 960.898
R126 VSS.t15 VSS.t2 818.312
R127 VSS.t0 VSS.t4 784.216
R128 VSS.t2 VSS.t0 722.222
R129 VSS.t6 VSS.t9 579.029
R130 VSS.t18 VSS.t17 464.95
R131 VSS.n176 VSS.t19 371.961
R132 VSS.n177 VSS.t7 252.268
R133 VSS.t20 VSS.n175 203.613
R134 VSS.n176 VSS.t20 90.1369
R135 VSS.n27 VSS.t11 38.0592
R136 VSS.t7 VSS.n27 19.799
R137 VSS.n222 VSS.t21 13.2818
R138 VSS.n222 VSS.t8 12.6131
R139 VSS.n223 VSS.n222 12.5472
R140 VSS.n135 VSS.t3 10.8416
R141 VSS.n137 VSS.t1 10.8416
R142 VSS.n1 VSS.t5 10.8416
R143 VSS.n227 VSS.t10 4.9955
R144 VSS.n86 VSS.n85 4.5591
R145 VSS.n229 VSS.n228 4.51164
R146 VSS.n134 VSS.t16 2.7892
R147 VSS.n84 VSS.t14 1.86768
R148 VSS.n192 VSS.t12 1.86768
R149 VSS.n87 VSS.n44 1.5755
R150 VSS.n140 VSS.n132 1.5755
R151 VSS.n79 VSS.n48 1.5755
R152 VSS.n221 VSS.n220 1.5755
R153 VSS.n229 VSS.n1 1.52994
R154 VSS.n220 VSS.n219 1.5005
R155 VSS.n6 VSS.n5 1.5005
R156 VSS.n214 VSS.n213 1.5005
R157 VSS.n212 VSS.n211 1.5005
R158 VSS.n10 VSS.n9 1.5005
R159 VSS.n206 VSS.n205 1.5005
R160 VSS.n204 VSS.n203 1.5005
R161 VSS.n14 VSS.n13 1.5005
R162 VSS.n198 VSS.n197 1.5005
R163 VSS.n196 VSS.n195 1.5005
R164 VSS.n18 VSS.n17 1.5005
R165 VSS.n180 VSS.n179 1.5005
R166 VSS.n26 VSS.n25 1.5005
R167 VSS.n186 VSS.n185 1.5005
R168 VSS.n188 VSS.n187 1.5005
R169 VSS.n24 VSS.n22 1.5005
R170 VSS.n62 VSS.n61 1.5005
R171 VSS.n64 VSS.n63 1.5005
R172 VSS.n56 VSS.n55 1.5005
R173 VSS.n70 VSS.n69 1.5005
R174 VSS.n72 VSS.n71 1.5005
R175 VSS.n51 VSS.n50 1.5005
R176 VSS.n78 VSS.n77 1.5005
R177 VSS.n80 VSS.n79 1.5005
R178 VSS.n85 VSS.n84 1.5005
R179 VSS.n83 VSS.n46 1.5005
R180 VSS.n82 VSS.n81 1.5005
R181 VSS.n49 VSS.n47 1.5005
R182 VSS.n76 VSS.n75 1.5005
R183 VSS.n74 VSS.n73 1.5005
R184 VSS.n57 VSS.n54 1.5005
R185 VSS.n68 VSS.n67 1.5005
R186 VSS.n66 VSS.n65 1.5005
R187 VSS.n59 VSS.n58 1.5005
R188 VSS.n60 VSS.n20 1.5005
R189 VSS.n190 VSS.n189 1.5005
R190 VSS.n23 VSS.n21 1.5005
R191 VSS.n184 VSS.n183 1.5005
R192 VSS.n182 VSS.n181 1.5005
R193 VSS.n178 VSS.n19 1.5005
R194 VSS.n194 VSS.n193 1.5005
R195 VSS.n16 VSS.n15 1.5005
R196 VSS.n200 VSS.n199 1.5005
R197 VSS.n202 VSS.n201 1.5005
R198 VSS.n12 VSS.n11 1.5005
R199 VSS.n208 VSS.n207 1.5005
R200 VSS.n210 VSS.n209 1.5005
R201 VSS.n8 VSS.n7 1.5005
R202 VSS.n216 VSS.n215 1.5005
R203 VSS.n218 VSS.n217 1.5005
R204 VSS.n4 VSS.n3 1.5005
R205 VSS.n225 VSS.n224 1.5005
R206 VSS.n226 VSS.n2 1.5005
R207 VSS.n133 VSS.n132 1.5005
R208 VSS.n146 VSS.n145 1.5005
R209 VSS.n148 VSS.n147 1.5005
R210 VSS.n129 VSS.n128 1.5005
R211 VSS.n154 VSS.n153 1.5005
R212 VSS.n156 VSS.n155 1.5005
R213 VSS.n125 VSS.n124 1.5005
R214 VSS.n162 VSS.n161 1.5005
R215 VSS.n164 VSS.n163 1.5005
R216 VSS.n121 VSS.n120 1.5005
R217 VSS.n170 VSS.n169 1.5005
R218 VSS.n172 VSS.n171 1.5005
R219 VSS.n119 VSS.n30 1.5005
R220 VSS.n118 VSS.n117 1.5005
R221 VSS.n33 VSS.n32 1.5005
R222 VSS.n111 VSS.n110 1.5005
R223 VSS.n109 VSS.n108 1.5005
R224 VSS.n37 VSS.n36 1.5005
R225 VSS.n103 VSS.n102 1.5005
R226 VSS.n101 VSS.n100 1.5005
R227 VSS.n41 VSS.n40 1.5005
R228 VSS.n95 VSS.n94 1.5005
R229 VSS.n93 VSS.n92 1.5005
R230 VSS.n45 VSS.n44 1.5005
R231 VSS.n89 VSS.n88 1.5005
R232 VSS.n91 VSS.n90 1.5005
R233 VSS.n43 VSS.n42 1.5005
R234 VSS.n97 VSS.n96 1.5005
R235 VSS.n99 VSS.n98 1.5005
R236 VSS.n39 VSS.n38 1.5005
R237 VSS.n105 VSS.n104 1.5005
R238 VSS.n107 VSS.n106 1.5005
R239 VSS.n35 VSS.n34 1.5005
R240 VSS.n113 VSS.n112 1.5005
R241 VSS.n115 VSS.n114 1.5005
R242 VSS.n116 VSS.n28 1.5005
R243 VSS.n174 VSS.n173 1.5005
R244 VSS.n31 VSS.n29 1.5005
R245 VSS.n168 VSS.n167 1.5005
R246 VSS.n166 VSS.n165 1.5005
R247 VSS.n123 VSS.n122 1.5005
R248 VSS.n160 VSS.n159 1.5005
R249 VSS.n158 VSS.n157 1.5005
R250 VSS.n127 VSS.n126 1.5005
R251 VSS.n152 VSS.n151 1.5005
R252 VSS.n150 VSS.n149 1.5005
R253 VSS.n131 VSS.n130 1.5005
R254 VSS.n144 VSS.n143 1.5005
R255 VSS.n142 VSS.n141 1.5005
R256 VSS.n139 VSS.n138 1.5005
R257 VSS.n136 VSS.n0 1.5005
R258 VSS.n191 VSS.n190 1.48306
R259 VSS.n53 VSS.n52 1.48306
R260 VSS.n228 VSS.n227 0.823286
R261 VSS.n89 VSS.n86 0.584164
R262 VSS.n191 VSS.t13 0.385115
R263 VSS.t12 VSS.n191 0.385115
R264 VSS.n52 VSS.t14 0.385115
R265 VSS.n52 VSS.t13 0.385115
R266 VSS.n228 VSS.n2 0.109929
R267 VSS.n87 VSS.n86 0.0957116
R268 VSS.n93 VSS.n44 0.0755
R269 VSS.n94 VSS.n93 0.0755
R270 VSS.n94 VSS.n40 0.0755
R271 VSS.n101 VSS.n40 0.0755
R272 VSS.n102 VSS.n101 0.0755
R273 VSS.n102 VSS.n36 0.0755
R274 VSS.n109 VSS.n36 0.0755
R275 VSS.n110 VSS.n109 0.0755
R276 VSS.n110 VSS.n32 0.0755
R277 VSS.n118 VSS.n32 0.0755
R278 VSS.n119 VSS.n118 0.0755
R279 VSS.n171 VSS.n119 0.0755
R280 VSS.n171 VSS.n170 0.0755
R281 VSS.n170 VSS.n120 0.0755
R282 VSS.n163 VSS.n120 0.0755
R283 VSS.n163 VSS.n162 0.0755
R284 VSS.n162 VSS.n124 0.0755
R285 VSS.n155 VSS.n124 0.0755
R286 VSS.n155 VSS.n154 0.0755
R287 VSS.n154 VSS.n128 0.0755
R288 VSS.n147 VSS.n128 0.0755
R289 VSS.n147 VSS.n146 0.0755
R290 VSS.n146 VSS.n132 0.0755
R291 VSS.n90 VSS.n89 0.0755
R292 VSS.n90 VSS.n42 0.0755
R293 VSS.n97 VSS.n42 0.0755
R294 VSS.n98 VSS.n97 0.0755
R295 VSS.n98 VSS.n38 0.0755
R296 VSS.n105 VSS.n38 0.0755
R297 VSS.n106 VSS.n105 0.0755
R298 VSS.n106 VSS.n34 0.0755
R299 VSS.n113 VSS.n34 0.0755
R300 VSS.n114 VSS.n113 0.0755
R301 VSS.n114 VSS.n28 0.0755
R302 VSS.n174 VSS.n29 0.0755
R303 VSS.n167 VSS.n29 0.0755
R304 VSS.n167 VSS.n166 0.0755
R305 VSS.n166 VSS.n122 0.0755
R306 VSS.n159 VSS.n122 0.0755
R307 VSS.n159 VSS.n158 0.0755
R308 VSS.n158 VSS.n126 0.0755
R309 VSS.n151 VSS.n126 0.0755
R310 VSS.n151 VSS.n150 0.0755
R311 VSS.n150 VSS.n130 0.0755
R312 VSS.n143 VSS.n142 0.0755
R313 VSS.n84 VSS.n83 0.0755
R314 VSS.n83 VSS.n82 0.0755
R315 VSS.n82 VSS.n47 0.0755
R316 VSS.n75 VSS.n47 0.0755
R317 VSS.n75 VSS.n74 0.0755
R318 VSS.n67 VSS.n57 0.0755
R319 VSS.n67 VSS.n66 0.0755
R320 VSS.n66 VSS.n58 0.0755
R321 VSS.n58 VSS.n20 0.0755
R322 VSS.n190 VSS.n20 0.0755
R323 VSS.n190 VSS.n21 0.0755
R324 VSS.n183 VSS.n21 0.0755
R325 VSS.n183 VSS.n182 0.0755
R326 VSS.n193 VSS.n19 0.0755
R327 VSS.n200 VSS.n15 0.0755
R328 VSS.n201 VSS.n200 0.0755
R329 VSS.n201 VSS.n11 0.0755
R330 VSS.n208 VSS.n11 0.0755
R331 VSS.n209 VSS.n208 0.0755
R332 VSS.n209 VSS.n7 0.0755
R333 VSS.n216 VSS.n7 0.0755
R334 VSS.n217 VSS.n216 0.0755
R335 VSS.n217 VSS.n3 0.0755
R336 VSS.n225 VSS.n3 0.0755
R337 VSS.n226 VSS.n225 0.0755
R338 VSS.n79 VSS.n78 0.0755
R339 VSS.n78 VSS.n50 0.0755
R340 VSS.n71 VSS.n50 0.0755
R341 VSS.n71 VSS.n70 0.0755
R342 VSS.n70 VSS.n55 0.0755
R343 VSS.n63 VSS.n55 0.0755
R344 VSS.n63 VSS.n62 0.0755
R345 VSS.n62 VSS.n24 0.0755
R346 VSS.n187 VSS.n24 0.0755
R347 VSS.n187 VSS.n186 0.0755
R348 VSS.n186 VSS.n25 0.0755
R349 VSS.n179 VSS.n25 0.0755
R350 VSS.n179 VSS.n17 0.0755
R351 VSS.n196 VSS.n17 0.0755
R352 VSS.n197 VSS.n196 0.0755
R353 VSS.n197 VSS.n13 0.0755
R354 VSS.n204 VSS.n13 0.0755
R355 VSS.n205 VSS.n204 0.0755
R356 VSS.n205 VSS.n9 0.0755
R357 VSS.n212 VSS.n9 0.0755
R358 VSS.n213 VSS.n212 0.0755
R359 VSS.n213 VSS.n5 0.0755
R360 VSS.n220 VSS.n5 0.0755
R361 VSS.n85 VSS.n46 0.0755
R362 VSS.n139 VSS.n0 0.0755
R363 VSS.n134 VSS.n130 0.0726875
R364 VSS.n138 VSS.n135 0.0584375
R365 VSS.n48 VSS.n46 0.0569375
R366 VSS.n81 VSS.n80 0.0569375
R367 VSS.n77 VSS.n49 0.0569375
R368 VSS.n76 VSS.n51 0.0569375
R369 VSS.n73 VSS.n72 0.0569375
R370 VSS.n69 VSS.n54 0.0569375
R371 VSS.n68 VSS.n56 0.0569375
R372 VSS.n65 VSS.n64 0.0569375
R373 VSS.n61 VSS.n59 0.0569375
R374 VSS.n60 VSS.n22 0.0569375
R375 VSS.n189 VSS.n188 0.0569375
R376 VSS.n185 VSS.n23 0.0569375
R377 VSS.n184 VSS.n26 0.0569375
R378 VSS.n181 VSS.n180 0.0569375
R379 VSS.n178 VSS.n18 0.0569375
R380 VSS.n195 VSS.n194 0.0569375
R381 VSS.n198 VSS.n16 0.0569375
R382 VSS.n199 VSS.n14 0.0569375
R383 VSS.n203 VSS.n202 0.0569375
R384 VSS.n206 VSS.n12 0.0569375
R385 VSS.n207 VSS.n10 0.0569375
R386 VSS.n211 VSS.n210 0.0569375
R387 VSS.n214 VSS.n8 0.0569375
R388 VSS.n215 VSS.n6 0.0569375
R389 VSS.n219 VSS.n218 0.0569375
R390 VSS.n221 VSS.n4 0.0569375
R391 VSS VSS.n0 0.054875
R392 VSS.n136 VSS.n1 0.0498125
R393 VSS.n88 VSS.n87 0.04925
R394 VSS.n91 VSS.n45 0.04925
R395 VSS.n92 VSS.n43 0.04925
R396 VSS.n96 VSS.n95 0.04925
R397 VSS.n99 VSS.n41 0.04925
R398 VSS.n100 VSS.n39 0.04925
R399 VSS.n104 VSS.n103 0.04925
R400 VSS.n107 VSS.n37 0.04925
R401 VSS.n108 VSS.n35 0.04925
R402 VSS.n112 VSS.n111 0.04925
R403 VSS.n115 VSS.n33 0.04925
R404 VSS.n117 VSS.n116 0.04925
R405 VSS.n173 VSS.n30 0.04925
R406 VSS.n172 VSS.n31 0.04925
R407 VSS.n169 VSS.n168 0.04925
R408 VSS.n165 VSS.n121 0.04925
R409 VSS.n164 VSS.n123 0.04925
R410 VSS.n161 VSS.n160 0.04925
R411 VSS.n157 VSS.n125 0.04925
R412 VSS.n156 VSS.n127 0.04925
R413 VSS.n153 VSS.n152 0.04925
R414 VSS.n149 VSS.n129 0.04925
R415 VSS.n148 VSS.n131 0.04925
R416 VSS.n145 VSS.n144 0.04925
R417 VSS.n141 VSS.n133 0.04925
R418 VSS.n140 VSS.n139 0.04925
R419 VSS.n223 VSS.n2 0.0490625
R420 VSS.n137 VSS.n136 0.0460625
R421 VSS.n175 VSS.n28 0.04175
R422 VSS.n182 VSS.n177 0.04175
R423 VSS.n74 VSS.n53 0.038
R424 VSS.n57 VSS.n53 0.038
R425 VSS.n193 VSS.n192 0.038
R426 VSS.n192 VSS.n15 0.038
R427 VSS.n175 VSS.n174 0.03425
R428 VSS.n177 VSS.n19 0.03425
R429 VSS.n138 VSS.n137 0.0299375
R430 VSS.n224 VSS.n223 0.0269375
R431 VSS.n88 VSS.n45 0.02675
R432 VSS.n92 VSS.n91 0.02675
R433 VSS.n95 VSS.n43 0.02675
R434 VSS.n96 VSS.n41 0.02675
R435 VSS.n100 VSS.n99 0.02675
R436 VSS.n103 VSS.n39 0.02675
R437 VSS.n104 VSS.n37 0.02675
R438 VSS.n108 VSS.n107 0.02675
R439 VSS.n111 VSS.n35 0.02675
R440 VSS.n112 VSS.n33 0.02675
R441 VSS.n117 VSS.n115 0.02675
R442 VSS.n116 VSS.n30 0.02675
R443 VSS.n173 VSS.n172 0.02675
R444 VSS.n169 VSS.n31 0.02675
R445 VSS.n168 VSS.n121 0.02675
R446 VSS.n165 VSS.n164 0.02675
R447 VSS.n161 VSS.n123 0.02675
R448 VSS.n160 VSS.n125 0.02675
R449 VSS.n157 VSS.n156 0.02675
R450 VSS.n153 VSS.n127 0.02675
R451 VSS.n152 VSS.n129 0.02675
R452 VSS.n149 VSS.n148 0.02675
R453 VSS.n145 VSS.n131 0.02675
R454 VSS.n144 VSS.n133 0.02675
R455 VSS.n141 VSS.n140 0.02675
R456 VSS.n81 VSS.n48 0.0190625
R457 VSS.n80 VSS.n49 0.0190625
R458 VSS.n77 VSS.n76 0.0190625
R459 VSS.n73 VSS.n51 0.0190625
R460 VSS.n72 VSS.n54 0.0190625
R461 VSS.n69 VSS.n68 0.0190625
R462 VSS.n65 VSS.n56 0.0190625
R463 VSS.n64 VSS.n59 0.0190625
R464 VSS.n61 VSS.n60 0.0190625
R465 VSS.n189 VSS.n22 0.0190625
R466 VSS.n188 VSS.n23 0.0190625
R467 VSS.n185 VSS.n184 0.0190625
R468 VSS.n181 VSS.n26 0.0190625
R469 VSS.n180 VSS.n178 0.0190625
R470 VSS.n194 VSS.n18 0.0190625
R471 VSS.n195 VSS.n16 0.0190625
R472 VSS.n199 VSS.n198 0.0190625
R473 VSS.n202 VSS.n14 0.0190625
R474 VSS.n203 VSS.n12 0.0190625
R475 VSS.n207 VSS.n206 0.0190625
R476 VSS.n210 VSS.n10 0.0190625
R477 VSS.n211 VSS.n8 0.0190625
R478 VSS.n215 VSS.n214 0.0190625
R479 VSS.n218 VSS.n6 0.0190625
R480 VSS.n219 VSS.n4 0.0190625
R481 VSS.n224 VSS.n221 0.0190625
R482 VSS.n142 VSS.n135 0.0175625
R483 VSS VSS.n229 0.017375
R484 VSS.n227 VSS.n226 0.005
R485 VSS.n143 VSS.n134 0.0033125
C0 enb x 0.45325f
C1 n2 x 0.42354f
C2 en vh 0.00139f
C3 nr vh 0.04885f
C4 vh VDD 1.29048f
C5 en nr 0.08089f
C6 nb x 2.18179f
C7 en VDD 0.43518f
C8 nr VDD 0.56081f
C9 enb vh 0.25355f
C10 n2 vh 2.80573f
C11 en enb 6.35468f
C12 nr enb 0.04735f
C13 en n2 0.18292f
C14 nr n2 1.21756f
C15 enb VDD 0.72196f
C16 n2 VDD 1.59517f
C17 nb vh 0.784f
C18 enb n2 0.11728f
C19 en nb 0.26886f
C20 nr nb 2.47068f
C21 nb VDD 2.51337f
C22 x vh 1.54113f
C23 enb nb 5.7547f
C24 n2 nb 3.63931f
C25 en x 0.03867f
C26 nr x 0.01134f
C27 x VDD 0.90319f
C28 en VSS 2.46861f
C29 enb VSS 1.00856f
C30 nb VSS 10.9957f
C31 VDD VSS 41.4597f
C32 vh VSS 1.06954f
C33 nr VSS 1.4407f
C34 n2 VSS 2.66427f
C35 x VSS 1.85652f
C36 VDD.n0 VSS -0.200235f
C37 VDD.t3 VSS 0.00774357f
C38 VDD.t1 VSS 0.0286504f
C39 VDD.n1 VSS 0.0721361f
C40 VDD.n2 VSS 0.0721361f
C41 VDD.n3 VSS 0.0721361f
C42 VDD.n4 VSS 0.0386407f
C43 VDD.n5 VSS 0.0721361f
C44 VDD.n6 VSS 0.0360681f
C45 VDD.n7 VSS 0.0721361f
C46 VDD.n8 VSS 0.0360681f
C47 VDD.n9 VSS 0.0721361f
C48 VDD.n10 VSS 0.0360681f
C49 VDD.n11 VSS 0.47451f
C50 VDD.n12 VSS 0.0360681f
C51 VDD.t2 VSS 0.146056f
C52 VDD.t0 VSS 0.258822f
C53 VDD.t4 VSS 0.0829754f
C54 VDD.n13 VSS 0.497372f
C55 VDD.t5 VSS 0.279729f
C56 VDD.t6 VSS 0.266369f
C57 VDD.t7 VSS 0.239716f
C58 VDD.t8 VSS 0.460961f
C59 VDD.n14 VSS 1.10856f
C60 VDD.n15 VSS 1.20798f
C61 VDD.n16 VSS 0.148157f
C62 VDD.n17 VSS 0.0523013f
C63 VDD.n18 VSS 0.0721361f
C64 VDD.n19 VSS 0.0360681f
C65 VDD.n20 VSS 0.0360681f
C66 VDD.n21 VSS 0.0721361f
C67 VDD.n22 VSS 0.0721361f
C68 VDD.n23 VSS 0.0360681f
C69 VDD.n24 VSS 0.0360681f
C70 VDD.n25 VSS 0.0721361f
C71 VDD.n26 VSS 0.0721361f
C72 VDD.n27 VSS 0.0360681f
C73 VDD.n28 VSS 0.0360681f
C74 VDD.n29 VSS 0.0721361f
C75 VDD.n30 VSS 0.123657f
C76 VDD.n31 VSS 0.0360681f
C77 VDD.n32 VSS 0.0360681f
C78 VDD.n33 VSS 0.0721361f
C79 VDD.n34 VSS 0.0721361f
C80 VDD.n35 VSS 0.0440003f
C81 VDD.n36 VSS 0.0547367f
C82 VDD.n37 VSS -0.00712614f
C83 VDD.n38 VSS 0.0721361f
C84 VDD.n39 VSS 0.0721361f
C85 VDD.n40 VSS 0.0721361f
C86 VDD.n41 VSS 0.0721361f
C87 VDD.n42 VSS -0.102947f
C88 VDD.n43 VSS -0.369505f
C89 VDD.n44 VSS 0.0502432f
C90 VDD.n45 VSS 0.0607652f
C91 VDD.n46 VSS 0.0456296f
C92 VDD.n47 VSS 0.0880435f
C93 nb.t10 VSS 2.22964f
C94 nb.t11 VSS 2.2003f
C95 nb.n0 VSS 0.45435f
C96 nb.t12 VSS 2.2003f
C97 nb.n1 VSS 0.233721f
C98 nb.t1 VSS 0.0423072f
C99 nb.t13 VSS 0.0163012f
C100 nb.n2 VSS 0.122088f
C101 nb.n3 VSS 0.126141f
C102 nb.t6 VSS 0.0288926f
C103 nb.n4 VSS 0.117966f
C104 nb.t3 VSS 0.103222f
C105 nb.t7 VSS 0.0240059f
C106 nb.n5 VSS 0.114985f
C107 nb.n6 VSS 0.0236576f
C108 nb.t8 VSS 0.0288926f
C109 nb.n7 VSS 0.0563023f
C110 nb.t9 VSS 0.0288926f
C111 nb.n8 VSS 0.0425711f
C112 nb.t0 VSS 0.0196839f
C113 nb.t2 VSS 0.103053f
C114 nb.t4 VSS 0.0240006f
C115 nb.n9 VSS 0.116193f
C116 nb.n10 VSS 0.0765403f
C117 nb.t5 VSS 0.0770891f
C118 nb.n11 VSS 0.0430829f
C119 nb.n12 VSS 0.0302699f
C120 enb.t1 VSS 0.038177f
C121 enb.t0 VSS 0.0135347f
C122 enb.n0 VSS 0.158349f
C123 enb.t4 VSS 0.0437948f
C124 enb.t3 VSS 0.00744357f
C125 enb.n1 VSS 0.126097f
C126 enb.n2 VSS 0.0584933f
C127 enb.t2 VSS 0.0143841f
C128 enb.n3 VSS 0.299916f
C129 en.t1 VSS 0.0236817f
C130 en.t0 VSS 0.0120054f
C131 en.n0 VSS 0.484456f
.ends
