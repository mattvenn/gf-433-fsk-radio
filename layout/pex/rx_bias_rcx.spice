* rx_bias: magic R+C extraction of layout/rx_bias.gds (layout/gen/pex.sh)
* rcfix.py: split-net C to VSS scaled by (S - K) / S on 4 nets (coupling double count removed)
* extracted 2026-11-16T12:08:55+01:00 with magic 8.3.642, mode rc, from rx_bias.gds
.subckt rx_bias VDD VSS en enb nb
X0 nr VSS.t22 VSS.t21 ppolyf_u r_width=2u r_length=29.72u
X1 x VSS.t23 vh VDD.t0 pfet_03v3 ad=0.42p pd=2.84u as=0.42p ps=2.84u w=0.42u l=10u
X2 nb.t3 nb.t2 VSS.t7 VSS.t6 nfet_03v3 ad=2p pd=6u as=2p ps=6u w=2u l=0.5u
X3 vh n2 nb.t0 VDD.t1 pfet_03v3 ad=2p pd=5u as=4p ps=10u w=4u l=1u
X4 nr nb.t13 n2 VSS.t2 nfet_03v3 ad=1p pd=3u as=2p ps=6u w=2u l=0.5u
X5 nb.t5 x n2 VSS.t16 nfet_03v3 ad=1p pd=4u as=1p ps=4u w=1u l=0.28u
X6 n2 n2 vh VDD.t2 pfet_03v3 ad=2p pd=5u as=2p ps=5u w=4u l=1u
X7 x enb.t2 VSS.t20 VSS.t19 nfet_03v3 ad=0.42p pd=2.84u as=0.42p ps=2.84u w=0.42u l=0.28u
X8 VSS.t15 nb.t6 VSS.t15 VSS.t14 nfet_03v3 ad=4.095p pd=9.19u as=0 ps=0 w=8.19u l=10u
X9 x nb.t9 VSS.t9 VSS.t8 nfet_03v3 ad=2p pd=6u as=2p ps=6u w=2u l=0.28u
X10 VSS.t13 nb.t7 VSS.t13 VSS.t12 nfet_03v3 ad=4.095p pd=9.19u as=0 ps=0 w=8.19u l=10u
X11 n2 nb.t12 nr VSS.t3 nfet_03v3 ad=2p pd=6u as=1p ps=3u w=2u l=0.5u
X12 nr nb.t11 n2 VSS.t4 nfet_03v3 ad=1p pd=3u as=2p ps=6u w=2u l=0.5u
X13 enb.t1 en.t1 VDD.t6 VDD.t5 pfet_03v3 ad=1p pd=4u as=0.45p ps=2.9u w=1u l=0.28u
X14 vh n2 n2 VDD.t3 pfet_03v3 ad=2p pd=5u as=2p ps=5u w=4u l=1u
X15 nb.t1 n2 vh VDD.t4 pfet_03v3 ad=4p pd=10u as=2p ps=5u w=4u l=1u
X16 enb.t0 en.t0 VSS.t1 VSS.t0 nfet_03v3 ad=0.42p pd=2.84u as=0.42p ps=2.84u w=0.42u l=0.28u
X17 VSS.t11 nb.t8 VSS.t11 VSS.t10 nfet_03v3 ad=8.19p pd=18.38u as=0 ps=0 w=8.19u l=10u
X18 n2 nb.t10 nr VSS.t5 nfet_03v3 ad=2p pd=6u as=1p ps=3u w=2u l=0.5u
X19 vh enb.t4 VDD.t8 VDD.t7 pfet_03v3 ad=4p pd=10u as=1.8p ps=8.9u w=4u l=0.28u
X20 nb.t4 enb.t3 VSS.t18 VSS.t17 nfet_03v3 ad=0.42p pd=2.84u as=0.42p ps=2.84u w=0.42u l=0.28u
R0 nb.n9 nb.t9 49.5512
R1 nb.n2 nb.t12 34.1482
R2 nb.n3 nb.t11 34.1482
R3 nb.n4 nb.t10 34.1482
R4 nb.n6 nb.t2 34.1482
R5 nb.n0 nb.t13 29.6429
R6 nb.n1 nb.t4 20.3042
R7 nb.n10 nb.t8 16.3654
R8 nb.n11 nb.t7 16.3654
R9 nb.n12 nb.t6 16.3654
R10 nb.n8 nb.t5 11.575
R11 nb.n7 nb.t3 8.54339
R12 nb.n5 nb.t1 7.41221
R13 nb.n1 nb.n0 4.5005
R14 nb nb.n9 4.34418
R15 nb.n0 nb.t0 2.90698
R16 nb.n12 nb.n11 2.60576
R17 nb.n11 nb.n10 2.60576
R18 nb.n10 nb 2.28366
R19 nb nb.n12 1.77682
R20 nb.n3 nb.n2 0.73471
R21 nb.n8 nb.n7 0.729974
R22 nb.n9 nb.n8 0.531026
R23 nb.n5 nb.n4 0.462342
R24 nb.n4 nb.n3 0.355763
R25 nb.n2 nb.n1 0.343921
R26 nb.n6 nb.n5 0.272868
R27 nb.n7 nb.n6 0.178132
R28 en.n0 en.t1 32.4282
R29 en.n0 en.t0 24.2884
R30 en en.n0 14.1814
R31 enb.n1 enb.t4 71.6567
R32 enb.n3 enb.t2 28.6326
R33 enb.n1 enb.t3 24.2179
R34 enb.n0 enb.t0 14.179
R35 enb enb.n3 8.34563
R36 enb.n0 enb.t1 7.44882
R37 enb.n2 enb.n0 4.94813
R38 enb.n2 enb.n1 4.5005
R39 enb.n3 enb.n2 0.812868
R40 VDD.n27 VDD.t0 5942.48
R41 VDD.t1 VDD.t7 3730.4
R42 VDD.t0 VDD.t4 2308.98
R43 VDD.t4 VDD.t3 284.495
R44 VDD.t3 VDD.t2 284.495
R45 VDD.t2 VDD.t1 284.495
R46 VDD.t7 VDD.t5 274.726
R47 VDD.n1 VDD.t6 5.42655
R48 VDD.n77 VDD.t8 1.73004
R49 VDD.n82 VDD.n81 1.5755
R50 VDD.n82 VDD.n1 1.55244
R51 VDD.n81 VDD.n80 1.5005
R52 VDD.n3 VDD.n2 1.5005
R53 VDD.n73 VDD.n72 1.5005
R54 VDD.n71 VDD.n70 1.5005
R55 VDD.n7 VDD.n6 1.5005
R56 VDD.n65 VDD.n64 1.5005
R57 VDD.n63 VDD.n62 1.5005
R58 VDD.n11 VDD.n10 1.5005
R59 VDD.n57 VDD.n56 1.5005
R60 VDD.n55 VDD.n54 1.5005
R61 VDD.n15 VDD.n14 1.5005
R62 VDD.n49 VDD.n48 1.5005
R63 VDD.n47 VDD.n46 1.5005
R64 VDD.n19 VDD.n18 1.5005
R65 VDD.n41 VDD.n40 1.5005
R66 VDD.n39 VDD.n38 1.5005
R67 VDD.n23 VDD.n22 1.5005
R68 VDD.n33 VDD.n32 1.5005
R69 VDD.n31 VDD.n30 1.5005
R70 VDD.n29 VDD.n28 1.5005
R71 VDD.n25 VDD.n24 1.5005
R72 VDD.n35 VDD.n34 1.5005
R73 VDD.n37 VDD.n36 1.5005
R74 VDD.n21 VDD.n20 1.5005
R75 VDD.n43 VDD.n42 1.5005
R76 VDD.n45 VDD.n44 1.5005
R77 VDD.n17 VDD.n16 1.5005
R78 VDD.n51 VDD.n50 1.5005
R79 VDD.n53 VDD.n52 1.5005
R80 VDD.n13 VDD.n12 1.5005
R81 VDD.n59 VDD.n58 1.5005
R82 VDD.n61 VDD.n60 1.5005
R83 VDD.n9 VDD.n8 1.5005
R84 VDD.n67 VDD.n66 1.5005
R85 VDD.n69 VDD.n68 1.5005
R86 VDD.n5 VDD.n4 1.5005
R87 VDD.n75 VDD.n74 1.5005
R88 VDD.n79 VDD.n78 1.5005
R89 VDD.n76 VDD.n0 1.5005
R90 VDD.n31 VDD.n26 0.354703
R91 VDD.n27 VDD.n26 0.343817
R92 VDD.n29 VDD.n26 0.124818
R93 VDD.n28 VDD.n24 0.0755
R94 VDD.n35 VDD.n24 0.0755
R95 VDD.n36 VDD.n35 0.0755
R96 VDD.n36 VDD.n20 0.0755
R97 VDD.n43 VDD.n20 0.0755
R98 VDD.n44 VDD.n43 0.0755
R99 VDD.n44 VDD.n16 0.0755
R100 VDD.n51 VDD.n16 0.0755
R101 VDD.n52 VDD.n51 0.0755
R102 VDD.n52 VDD.n12 0.0755
R103 VDD.n59 VDD.n12 0.0755
R104 VDD.n60 VDD.n59 0.0755
R105 VDD.n60 VDD.n8 0.0755
R106 VDD.n67 VDD.n8 0.0755
R107 VDD.n68 VDD.n67 0.0755
R108 VDD.n68 VDD.n4 0.0755
R109 VDD.n75 VDD.n4 0.0755
R110 VDD.n78 VDD.n75 0.0755
R111 VDD.n32 VDD.n31 0.0755
R112 VDD.n32 VDD.n22 0.0755
R113 VDD.n39 VDD.n22 0.0755
R114 VDD.n40 VDD.n39 0.0755
R115 VDD.n40 VDD.n18 0.0755
R116 VDD.n47 VDD.n18 0.0755
R117 VDD.n48 VDD.n47 0.0755
R118 VDD.n48 VDD.n14 0.0755
R119 VDD.n55 VDD.n14 0.0755
R120 VDD.n56 VDD.n55 0.0755
R121 VDD.n56 VDD.n10 0.0755
R122 VDD.n63 VDD.n10 0.0755
R123 VDD.n64 VDD.n63 0.0755
R124 VDD.n64 VDD.n6 0.0755
R125 VDD.n71 VDD.n6 0.0755
R126 VDD.n72 VDD.n71 0.0755
R127 VDD.n72 VDD.n2 0.0755
R128 VDD.n81 VDD.n2 0.0755
R129 VDD.n30 VDD.n29 0.07175
R130 VDD.n33 VDD.n25 0.07175
R131 VDD.n34 VDD.n23 0.07175
R132 VDD.n38 VDD.n37 0.07175
R133 VDD.n41 VDD.n21 0.07175
R134 VDD.n42 VDD.n19 0.07175
R135 VDD.n46 VDD.n45 0.07175
R136 VDD.n49 VDD.n17 0.07175
R137 VDD.n50 VDD.n15 0.07175
R138 VDD.n54 VDD.n53 0.07175
R139 VDD.n57 VDD.n13 0.07175
R140 VDD.n58 VDD.n11 0.07175
R141 VDD.n62 VDD.n61 0.07175
R142 VDD.n65 VDD.n9 0.07175
R143 VDD.n66 VDD.n7 0.07175
R144 VDD.n70 VDD.n69 0.07175
R145 VDD.n73 VDD.n5 0.07175
R146 VDD.n74 VDD.n3 0.07175
R147 VDD.n80 VDD.n79 0.07175
R148 VDD.n77 VDD.n76 0.0685625
R149 VDD.n28 VDD.n27 0.0640625
R150 VDD VDD.n0 0.054875
R151 VDD.n76 VDD.n1 0.0273125
R152 VDD VDD.n82 0.017375
R153 VDD.n78 VDD.n77 0.0074375
R154 VDD.n30 VDD.n25 0.00425
R155 VDD.n34 VDD.n33 0.00425
R156 VDD.n37 VDD.n23 0.00425
R157 VDD.n38 VDD.n21 0.00425
R158 VDD.n42 VDD.n41 0.00425
R159 VDD.n45 VDD.n19 0.00425
R160 VDD.n46 VDD.n17 0.00425
R161 VDD.n50 VDD.n49 0.00425
R162 VDD.n53 VDD.n15 0.00425
R163 VDD.n54 VDD.n13 0.00425
R164 VDD.n58 VDD.n57 0.00425
R165 VDD.n61 VDD.n11 0.00425
R166 VDD.n62 VDD.n9 0.00425
R167 VDD.n66 VDD.n65 0.00425
R168 VDD.n69 VDD.n7 0.00425
R169 VDD.n70 VDD.n5 0.00425
R170 VDD.n74 VDD.n73 0.00425
R171 VDD.n79 VDD.n3 0.00425
R172 VDD.n80 VDD.n0 0.00425
R173 VSS.t0 VSS.t14 628638
R174 VSS.t21 VSS.t8 1882.72
R175 VSS.t14 VSS.t12 1560.11
R176 VSS.t12 VSS.t10 1560.11
R177 VSS.t21 VSS.t10 1205.54
R178 VSS.t16 VSS.t6 599.798
R179 VSS.t2 VSS.t19 599.798
R180 VSS.t17 VSS.t0 588.516
R181 VSS.t6 VSS.t5 582.875
R182 VSS.t4 VSS.t3 582.875
R183 VSS.t8 VSS.t16 541.51
R184 VSS.t19 VSS.t17 541.51
R185 VSS.t5 VSS.t4 282.036
R186 VSS.t3 VSS.t2 282.036
R187 VSS.n113 VSS.t21 51.2566
R188 VSS.n4 VSS.t20 15.8326
R189 VSS.n165 VSS.t18 15.8326
R190 VSS.n1 VSS.t1 15.8326
R191 VSS.n18 VSS.t23 13.3031
R192 VSS.n18 VSS.t22 12.8571
R193 VSS.n19 VSS.n18 12.5093
R194 VSS.n16 VSS.t9 4.9955
R195 VSS.n12 VSS.t7 4.9955
R196 VSS.n56 VSS.t15 1.86768
R197 VSS.t11 VSS.n32 1.86768
R198 VSS.n128 VSS.n127 1.5755
R199 VSS.n135 VSS.n134 1.5755
R200 VSS.n171 VSS.n170 1.5755
R201 VSS.n171 VSS.n1 1.54175
R202 VSS.n57 VSS.n56 1.53038
R203 VSS.n170 VSS.n169 1.5005
R204 VSS.n3 VSS.n2 1.5005
R205 VSS.n162 VSS.n161 1.5005
R206 VSS.n160 VSS.n159 1.5005
R207 VSS.n7 VSS.n6 1.5005
R208 VSS.n153 VSS.n152 1.5005
R209 VSS.n151 VSS.n150 1.5005
R210 VSS.n11 VSS.n10 1.5005
R211 VSS.n145 VSS.n144 1.5005
R212 VSS.n143 VSS.n142 1.5005
R213 VSS.n15 VSS.n14 1.5005
R214 VSS.n136 VSS.n135 1.5005
R215 VSS.n127 VSS.n21 1.5005
R216 VSS.n126 VSS.n125 1.5005
R217 VSS.n23 VSS.n22 1.5005
R218 VSS.n119 VSS.n118 1.5005
R219 VSS.n117 VSS.n116 1.5005
R220 VSS.n27 VSS.n26 1.5005
R221 VSS.n110 VSS.n109 1.5005
R222 VSS.n108 VSS.n107 1.5005
R223 VSS.n31 VSS.n30 1.5005
R224 VSS.n102 VSS.n101 1.5005
R225 VSS.n100 VSS.n99 1.5005
R226 VSS.n35 VSS.n34 1.5005
R227 VSS.n93 VSS.n92 1.5005
R228 VSS.n91 VSS.n90 1.5005
R229 VSS.n39 VSS.n38 1.5005
R230 VSS.n84 VSS.n83 1.5005
R231 VSS.n82 VSS.n81 1.5005
R232 VSS.n44 VSS.n43 1.5005
R233 VSS.n76 VSS.n75 1.5005
R234 VSS.n74 VSS.n73 1.5005
R235 VSS.n48 VSS.n47 1.5005
R236 VSS.n67 VSS.n66 1.5005
R237 VSS.n65 VSS.n64 1.5005
R238 VSS.n53 VSS.n52 1.5005
R239 VSS.n59 VSS.n58 1.5005
R240 VSS.n55 VSS.n54 1.5005
R241 VSS.n61 VSS.n60 1.5005
R242 VSS.n63 VSS.n62 1.5005
R243 VSS.n51 VSS.n50 1.5005
R244 VSS.n69 VSS.n68 1.5005
R245 VSS.n72 VSS.n71 1.5005
R246 VSS.n46 VSS.n45 1.5005
R247 VSS.n78 VSS.n77 1.5005
R248 VSS.n80 VSS.n79 1.5005
R249 VSS.n42 VSS.n41 1.5005
R250 VSS.n86 VSS.n85 1.5005
R251 VSS.n89 VSS.n88 1.5005
R252 VSS.n37 VSS.n36 1.5005
R253 VSS.n95 VSS.n94 1.5005
R254 VSS.n98 VSS.n97 1.5005
R255 VSS.n96 VSS.n33 1.5005
R256 VSS.n104 VSS.n103 1.5005
R257 VSS.n106 VSS.n105 1.5005
R258 VSS.n29 VSS.n28 1.5005
R259 VSS.n112 VSS.n111 1.5005
R260 VSS.n115 VSS.n114 1.5005
R261 VSS.n25 VSS.n24 1.5005
R262 VSS.n121 VSS.n120 1.5005
R263 VSS.n123 VSS.n122 1.5005
R264 VSS.n124 VSS.n20 1.5005
R265 VSS.n130 VSS.n129 1.5005
R266 VSS.n133 VSS.n132 1.5005
R267 VSS.n131 VSS.n17 1.5005
R268 VSS.n138 VSS.n137 1.5005
R269 VSS.n141 VSS.n140 1.5005
R270 VSS.n139 VSS.n13 1.5005
R271 VSS.n147 VSS.n146 1.5005
R272 VSS.n149 VSS.n148 1.5005
R273 VSS.n9 VSS.n8 1.5005
R274 VSS.n155 VSS.n154 1.5005
R275 VSS.n158 VSS.n157 1.5005
R276 VSS.n156 VSS.n5 1.5005
R277 VSS.n164 VSS.n163 1.5005
R278 VSS.n168 VSS.n167 1.5005
R279 VSS.n166 VSS.n0 1.5005
R280 VSS.n70 VSS.n49 1.48306
R281 VSS.n87 VSS.n40 1.48306
R282 VSS.n58 VSS.n57 0.848768
R283 VSS.t15 VSS.n49 0.385115
R284 VSS.n49 VSS.t13 0.385115
R285 VSS.t13 VSS.n40 0.385115
R286 VSS.n40 VSS.t11 0.385115
R287 VSS.n61 VSS.n54 0.0755
R288 VSS.n62 VSS.n61 0.0755
R289 VSS.n62 VSS.n50 0.0755
R290 VSS.n69 VSS.n50 0.0755
R291 VSS.n71 VSS.n45 0.0755
R292 VSS.n78 VSS.n45 0.0755
R293 VSS.n79 VSS.n78 0.0755
R294 VSS.n79 VSS.n41 0.0755
R295 VSS.n86 VSS.n41 0.0755
R296 VSS.n88 VSS.n36 0.0755
R297 VSS.n95 VSS.n36 0.0755
R298 VSS.n97 VSS.n95 0.0755
R299 VSS.n97 VSS.n96 0.0755
R300 VSS.n105 VSS.n104 0.0755
R301 VSS.n105 VSS.n28 0.0755
R302 VSS.n112 VSS.n28 0.0755
R303 VSS.n114 VSS.n24 0.0755
R304 VSS.n121 VSS.n24 0.0755
R305 VSS.n122 VSS.n121 0.0755
R306 VSS.n122 VSS.n20 0.0755
R307 VSS.n130 VSS.n20 0.0755
R308 VSS.n132 VSS.n130 0.0755
R309 VSS.n132 VSS.n131 0.0755
R310 VSS.n140 VSS.n138 0.0755
R311 VSS.n140 VSS.n139 0.0755
R312 VSS.n148 VSS.n147 0.0755
R313 VSS.n148 VSS.n8 0.0755
R314 VSS.n155 VSS.n8 0.0755
R315 VSS.n157 VSS.n155 0.0755
R316 VSS.n157 VSS.n156 0.0755
R317 VSS.n167 VSS.n166 0.0755
R318 VSS.n58 VSS.n52 0.0755
R319 VSS.n65 VSS.n52 0.0755
R320 VSS.n66 VSS.n65 0.0755
R321 VSS.n66 VSS.n47 0.0755
R322 VSS.n74 VSS.n47 0.0755
R323 VSS.n75 VSS.n74 0.0755
R324 VSS.n75 VSS.n43 0.0755
R325 VSS.n82 VSS.n43 0.0755
R326 VSS.n83 VSS.n82 0.0755
R327 VSS.n83 VSS.n38 0.0755
R328 VSS.n91 VSS.n38 0.0755
R329 VSS.n92 VSS.n91 0.0755
R330 VSS.n92 VSS.n34 0.0755
R331 VSS.n100 VSS.n34 0.0755
R332 VSS.n101 VSS.n100 0.0755
R333 VSS.n101 VSS.n30 0.0755
R334 VSS.n108 VSS.n30 0.0755
R335 VSS.n109 VSS.n108 0.0755
R336 VSS.n109 VSS.n26 0.0755
R337 VSS.n117 VSS.n26 0.0755
R338 VSS.n118 VSS.n117 0.0755
R339 VSS.n118 VSS.n22 0.0755
R340 VSS.n126 VSS.n22 0.0755
R341 VSS.n127 VSS.n126 0.0755
R342 VSS.n135 VSS.n14 0.0755
R343 VSS.n143 VSS.n14 0.0755
R344 VSS.n144 VSS.n143 0.0755
R345 VSS.n144 VSS.n10 0.0755
R346 VSS.n151 VSS.n10 0.0755
R347 VSS.n152 VSS.n151 0.0755
R348 VSS.n152 VSS.n6 0.0755
R349 VSS.n160 VSS.n6 0.0755
R350 VSS.n161 VSS.n160 0.0755
R351 VSS.n161 VSS.n2 0.0755
R352 VSS.n170 VSS.n2 0.0755
R353 VSS.n134 VSS.n133 0.07175
R354 VSS.n136 VSS.n17 0.07175
R355 VSS.n137 VSS.n15 0.07175
R356 VSS.n142 VSS.n141 0.07175
R357 VSS.n145 VSS.n13 0.07175
R358 VSS.n146 VSS.n11 0.07175
R359 VSS.n150 VSS.n149 0.07175
R360 VSS.n153 VSS.n9 0.07175
R361 VSS.n154 VSS.n7 0.07175
R362 VSS.n159 VSS.n158 0.07175
R363 VSS.n162 VSS.n5 0.07175
R364 VSS.n163 VSS.n3 0.07175
R365 VSS.n169 VSS.n168 0.07175
R366 VSS.n165 VSS.n164 0.070625
R367 VSS.n114 VSS.n113 0.0640625
R368 VSS.n57 VSS.n55 0.0617589
R369 VSS.n56 VSS.n54 0.060125
R370 VSS.n88 VSS.n87 0.060125
R371 VSS.n138 VSS.n16 0.055625
R372 VSS VSS.n0 0.054875
R373 VSS.n70 VSS.n69 0.053375
R374 VSS.n96 VSS.n32 0.053375
R375 VSS.n147 VSS.n12 0.048875
R376 VSS.n60 VSS.n59 0.0483125
R377 VSS.n63 VSS.n53 0.0483125
R378 VSS.n64 VSS.n51 0.0483125
R379 VSS.n68 VSS.n67 0.0483125
R380 VSS.n72 VSS.n48 0.0483125
R381 VSS.n73 VSS.n46 0.0483125
R382 VSS.n77 VSS.n76 0.0483125
R383 VSS.n80 VSS.n44 0.0483125
R384 VSS.n81 VSS.n42 0.0483125
R385 VSS.n85 VSS.n84 0.0483125
R386 VSS.n89 VSS.n39 0.0483125
R387 VSS.n90 VSS.n37 0.0483125
R388 VSS.n94 VSS.n93 0.0483125
R389 VSS.n98 VSS.n35 0.0483125
R390 VSS.n99 VSS.n33 0.0483125
R391 VSS.n103 VSS.n102 0.0483125
R392 VSS.n106 VSS.n31 0.0483125
R393 VSS.n107 VSS.n29 0.0483125
R394 VSS.n111 VSS.n110 0.0483125
R395 VSS.n115 VSS.n27 0.0483125
R396 VSS.n116 VSS.n25 0.0483125
R397 VSS.n120 VSS.n119 0.0483125
R398 VSS.n123 VSS.n23 0.0483125
R399 VSS.n125 VSS.n124 0.0483125
R400 VSS.n129 VSS.n21 0.0483125
R401 VSS.n128 VSS.n19 0.0455
R402 VSS.n164 VSS.n4 0.038375
R403 VSS.n166 VSS.n1 0.038
R404 VSS.n156 VSS.n4 0.037625
R405 VSS.n59 VSS.n55 0.0276875
R406 VSS.n60 VSS.n53 0.0276875
R407 VSS.n64 VSS.n63 0.0276875
R408 VSS.n67 VSS.n51 0.0276875
R409 VSS.n68 VSS.n48 0.0276875
R410 VSS.n73 VSS.n72 0.0276875
R411 VSS.n76 VSS.n46 0.0276875
R412 VSS.n77 VSS.n44 0.0276875
R413 VSS.n81 VSS.n80 0.0276875
R414 VSS.n84 VSS.n42 0.0276875
R415 VSS.n85 VSS.n39 0.0276875
R416 VSS.n90 VSS.n89 0.0276875
R417 VSS.n93 VSS.n37 0.0276875
R418 VSS.n94 VSS.n35 0.0276875
R419 VSS.n99 VSS.n98 0.0276875
R420 VSS.n102 VSS.n33 0.0276875
R421 VSS.n103 VSS.n31 0.0276875
R422 VSS.n107 VSS.n106 0.0276875
R423 VSS.n110 VSS.n29 0.0276875
R424 VSS.n111 VSS.n27 0.0276875
R425 VSS.n116 VSS.n115 0.0276875
R426 VSS.n119 VSS.n25 0.0276875
R427 VSS.n120 VSS.n23 0.0276875
R428 VSS.n125 VSS.n123 0.0276875
R429 VSS.n124 VSS.n21 0.0276875
R430 VSS.n129 VSS.n128 0.0276875
R431 VSS.n139 VSS.n12 0.027125
R432 VSS.n71 VSS.n70 0.022625
R433 VSS.n104 VSS.n32 0.022625
R434 VSS.n131 VSS.n16 0.020375
R435 VSS VSS.n171 0.017375
R436 VSS.n87 VSS.n86 0.015875
R437 VSS.n113 VSS.n112 0.0119375
R438 VSS.n167 VSS.n165 0.005375
R439 VSS.n134 VSS.n17 0.00425
R440 VSS.n137 VSS.n136 0.00425
R441 VSS.n141 VSS.n15 0.00425
R442 VSS.n142 VSS.n13 0.00425
R443 VSS.n146 VSS.n145 0.00425
R444 VSS.n149 VSS.n11 0.00425
R445 VSS.n150 VSS.n9 0.00425
R446 VSS.n154 VSS.n153 0.00425
R447 VSS.n158 VSS.n7 0.00425
R448 VSS.n159 VSS.n5 0.00425
R449 VSS.n163 VSS.n162 0.00425
R450 VSS.n168 VSS.n3 0.00425
R451 VSS.n169 VSS.n0 0.00425
R452 VSS.n133 VSS.n19 0.0033125
C0 nr x 2.01867f
C1 vh nb 0.50199f
C2 en n2 0.13872f
C3 en enb 8.23334f
C4 nb x 3.46277f
C5 en VDD 0.15211f
C6 enb n2 0.23355f
C7 n2 VDD 1.20507f
C8 vh x 0.04565f
C9 en nr 0.08924f
C10 enb VDD 0.35099f
C11 nr n2 1.70971f
C12 en nb 7.0491f
C13 enb nr 0.15069f
C14 nr VDD 0.0911f
C15 nb n2 2.72095f
C16 en vh 0.01039f
C17 enb nb 1.59554f
C18 nb VDD 0.31198f
C19 en x 0.08631f
C20 vh n2 2.36305f
C21 enb vh 0.25426f
C22 nr nb 1.95029f
C23 n2 x 1.00468f
C24 vh VDD 0.88556f
C25 enb x 0.38913f
C26 x VDD 0.05397f
C27 nr vh 0.00432f
C28 nb VSS 7.92956f
C29 en VSS 1.10053f
C30 enb VSS 2.3569f
C31 VDD VSS 49.1976f
C32 nr VSS 2.21322f
C33 x VSS 1.58537f
C34 vh VSS 0.61522f
C35 n2 VSS 1.95636f
C36 VDD.n0 VSS 0.00624417f
C37 VDD.t6 VSS 0.00172872f
C38 VDD.n1 VSS 0.0218688f
C39 VDD.n2 VSS 0.0161253f
C40 VDD.n3 VSS 0.0080579f
C41 VDD.n4 VSS 0.0161253f
C42 VDD.n5 VSS 0.0080579f
C43 VDD.n6 VSS 0.0161253f
C44 VDD.n7 VSS 0.0080579f
C45 VDD.n8 VSS 0.0161253f
C46 VDD.n9 VSS 0.0080579f
C47 VDD.n10 VSS 0.0161253f
C48 VDD.n11 VSS 0.0080579f
C49 VDD.n12 VSS 0.0161253f
C50 VDD.n13 VSS 0.0080579f
C51 VDD.n14 VSS 0.0161253f
C52 VDD.n15 VSS 0.0080579f
C53 VDD.n16 VSS 0.0161253f
C54 VDD.n17 VSS 0.0080579f
C55 VDD.n18 VSS 0.0161253f
C56 VDD.n19 VSS 0.0080579f
C57 VDD.n20 VSS 0.0161253f
C58 VDD.n21 VSS 0.0080579f
C59 VDD.n22 VSS 0.0161253f
C60 VDD.n23 VSS 0.0080579f
C61 VDD.n24 VSS 0.0161253f
C62 VDD.n25 VSS 0.0080579f
C63 VDD.n26 VSS 0.559595f
C64 VDD.t5 VSS 0.0326473f
C65 VDD.t7 VSS 0.0945505f
C66 VDD.t1 VSS 0.089421f
C67 VDD.t2 VSS 0.0472233f
C68 VDD.t3 VSS 0.0472233f
C69 VDD.t4 VSS 0.106179f
C70 VDD.t0 VSS 0.287326f
C71 VDD.n27 VSS 0.418227f
C72 VDD.n28 VSS 0.0148972f
C73 VDD.n29 VSS 0.0350656f
C74 VDD.n30 VSS 0.0080579f
C75 VDD.n31 VSS 0.192284f
C76 VDD.n32 VSS 0.0161253f
C77 VDD.n33 VSS 0.0080579f
C78 VDD.n34 VSS 0.0080579f
C79 VDD.n35 VSS 0.0161253f
C80 VDD.n36 VSS 0.0161253f
C81 VDD.n37 VSS 0.0080579f
C82 VDD.n38 VSS 0.0080579f
C83 VDD.n39 VSS 0.0161253f
C84 VDD.n40 VSS 0.0161253f
C85 VDD.n41 VSS 0.0080579f
C86 VDD.n42 VSS 0.0080579f
C87 VDD.n43 VSS 0.0161253f
C88 VDD.n44 VSS 0.0161253f
C89 VDD.n45 VSS 0.0080579f
C90 VDD.n46 VSS 0.0080579f
C91 VDD.n47 VSS 0.0161253f
C92 VDD.n48 VSS 0.0161253f
C93 VDD.n49 VSS 0.0080579f
C94 VDD.n50 VSS 0.0080579f
C95 VDD.n51 VSS 0.0161253f
C96 VDD.n52 VSS 0.0161253f
C97 VDD.n53 VSS 0.0080579f
C98 VDD.n54 VSS 0.0080579f
C99 VDD.n55 VSS 0.0161253f
C100 VDD.n56 VSS 0.0161253f
C101 VDD.n57 VSS 0.0080579f
C102 VDD.n58 VSS 0.0080579f
C103 VDD.n59 VSS 0.0161253f
C104 VDD.n60 VSS 0.0161253f
C105 VDD.n61 VSS 0.0080579f
C106 VDD.n62 VSS 0.0080579f
C107 VDD.n63 VSS 0.0161253f
C108 VDD.n64 VSS 0.0161253f
C109 VDD.n65 VSS 0.0080579f
C110 VDD.n66 VSS 0.0080579f
C111 VDD.n67 VSS 0.0161253f
C112 VDD.n68 VSS 0.0161253f
C113 VDD.n69 VSS 0.0080579f
C114 VDD.n70 VSS 0.0080579f
C115 VDD.n71 VSS 0.0161253f
C116 VDD.n72 VSS 0.0161253f
C117 VDD.n73 VSS 0.0080579f
C118 VDD.n74 VSS 0.0080579f
C119 VDD.n75 VSS 0.0161253f
C120 VDD.t8 VSS 0.00640476f
C121 VDD.n76 VSS 0.0102023f
C122 VDD.n77 VSS 0.0135841f
C123 VDD.n78 VSS 0.00880418f
C124 VDD.n79 VSS 0.0080579f
C125 VDD.n80 VSS 0.0080579f
C126 VDD.n81 VSS 0.0276406f
C127 VDD.n82 VSS 0.00666926f
C128 enb.t1 VSS 0.0589375f
C129 enb.t0 VSS 0.017696f
C130 enb.n0 VSS 0.228109f
C131 enb.t4 VSS 0.0605093f
C132 enb.t3 VSS 0.0100305f
C133 enb.n1 VSS 0.202005f
C134 enb.n2 VSS 0.0953258f
C135 enb.t2 VSS 0.0164724f
C136 enb.n3 VSS 0.528523f
C137 en.t1 VSS 0.0110075f
C138 en.t0 VSS 0.00573667f
C139 en.n0 VSS 0.30167f
C140 nb.t4 VSS 0.0197923f
C141 nb.t0 VSS 0.103183f
C142 nb.t13 VSS 0.0229497f
C143 nb.n0 VSS 0.111036f
C144 nb.n1 VSS 0.0872856f
C145 nb.t12 VSS 0.0275301f
C146 nb.n2 VSS 0.0525257f
C147 nb.t11 VSS 0.0275301f
C148 nb.n3 VSS 0.05277f
C149 nb.t10 VSS 0.0275301f
C150 nb.n4 VSS 0.0471116f
C151 nb.t1 VSS 0.151535f
C152 nb.n5 VSS 0.0464457f
C153 nb.t2 VSS 0.0275301f
C154 nb.n6 VSS 0.0394889f
C155 nb.t3 VSS 0.0733146f
C156 nb.n7 VSS 0.046139f
C157 nb.t5 VSS 0.0371747f
C158 nb.n8 VSS 0.0538816f
C159 nb.t9 VSS 0.0152503f
C160 nb.n9 VSS 0.130842f
C161 nb.t8 VSS 2.10275f
C162 nb.n10 VSS 0.249069f
C163 nb.t7 VSS 2.10275f
C164 nb.n11 VSS 0.255758f
C165 nb.t6 VSS 2.10275f
C166 nb.n12 VSS 0.238543f
.ends
