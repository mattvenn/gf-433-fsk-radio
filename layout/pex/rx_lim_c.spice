* rx_lim: magic R+C extraction of layout/rx_lim.gds (layout/gen/pex.sh)
* extracted 2026-11-16T12:09:02+01:00 with magic 8.3.642, mode c, from rx_lim.gds
.subckt rx_lim VDD VSS inp inn q nb enb
X0 ct nb VSS VSS nfet_03v3 ad=2p pd=6u as=0.9p ps=4.9u w=2u l=0.5u
X1 gcn vgr vb vb pfet_03v3 ad=0.42p pd=2.84u as=0.42p ps=2.84u w=0.42u l=12u
X2 inp glp inp inp pfet_03v3 ad=12.285p pd=26.57u as=24.57p ps=53.14u w=12.285u l=10u
X3 ln gcn ln ln pfet_03v3 ad=12.285p pd=26.57u as=24.57p ps=53.14u w=12.285u l=10u
X4 VSS vb VSS VSS nfet_03v3 ad=12.285p pd=26.57u as=40.869p ps=0.10385m w=12.285u l=10u
X5 mRpLa mRpLa vb vb pfet_03v3 ad=0.42p pd=2.84u as=0.42p ps=2.84u w=0.42u l=1u
X6 ln glp tL VSS nfet_03v3 ad=4p pd=10u as=2p ps=5u w=4u l=0.5u
X7 cb cb VDD VDD pfet_03v3 ad=1p pd=4u as=0.45p ps=2.9u w=1u l=0.5u
X8 cq co VSS VSS nfet_03v3 ad=0.5p pd=3u as=0.225p ps=1.9u w=0.5u l=0.28u
X9 cx cb VDD VDD pfet_03v3 ad=2p pd=6u as=0.9p ps=4.9u w=2u l=0.5u
X10 cx cx VSS VSS nfet_03v3 ad=1p pd=4u as=0.45p ps=2.9u w=1u l=0.5u
X11 co cx VSS VSS nfet_03v3 ad=1p pd=4u as=0.45p ps=2.9u w=1u l=0.5u
X12 vb vbt VSS ppolyf_u_1k r_width=1u r_length=0.15m
X13 q cq VDD VDD pfet_03v3 ad=5p pd=12u as=2.25p ps=10.9u w=5u l=0.28u
X14 cb ca VDD VDD pfet_03v3 ad=1.7p pd=5.4u as=0.765p ps=4.3u w=1.7u l=0.5u
X15 lp gcp lp lp pfet_03v3 ad=12.285p pd=26.57u as=24.57p ps=53.14u w=12.285u l=10u
X16 tL nb VSS VSS nfet_03v3 ad=2p pd=6u as=0.9p ps=4.9u w=2u l=0.5u
X17 q cq VSS VSS nfet_03v3 ad=2p pd=6u as=0.9p ps=4.9u w=2u l=0.28u
X18 VSS vb VSS VSS nfet_03v3 ad=6.1425p pd=13.285u as=0 ps=0 w=12.285u l=10u
X19 VSS nb vgr VSS nfet_03v3 ad=0.189p pd=1.74u as=0.42p ps=2.84u w=0.42u l=50u
X20 cq co VDD VDD pfet_03v3 ad=1.25p pd=4.5u as=0.5625p ps=3.4u w=1.25u l=0.28u
X21 mRpCa mRpCa vb vb pfet_03v3 ad=0.42p pd=2.84u as=0.42p ps=2.84u w=0.42u l=1u
X22 inn gln inn inn pfet_03v3 ad=12.285p pd=26.57u as=24.57p ps=53.14u w=12.285u l=10u
X23 mRpCa mRpCa gcp gcp pfet_03v3 ad=0.42p pd=2.84u as=0.42p ps=2.84u w=0.42u l=1u
X24 mRpLb mRpLb vb vb pfet_03v3 ad=0.42p pd=2.84u as=0.42p ps=2.84u w=0.42u l=1u
X25 gcp vgr vb vb pfet_03v3 ad=0.42p pd=2.84u as=0.42p ps=2.84u w=0.42u l=12u
X26 mRpCb mRpCb gcn gcn pfet_03v3 ad=0.42p pd=2.84u as=0.42p ps=2.84u w=0.42u l=1u
X27 glp vgr vb vb pfet_03v3 ad=0.42p pd=2.84u as=0.42p ps=2.84u w=0.42u l=12u
X28 gln vgr vb vb pfet_03v3 ad=0.42p pd=2.84u as=0.42p ps=2.84u w=0.42u l=12u
X29 mRpLb mRpLb gln gln pfet_03v3 ad=0.42p pd=2.84u as=0.42p ps=2.84u w=0.42u l=1u
X30 VSS vb VSS ppolyf_u_1k r_width=1u r_length=0.10002m
X31 mRpCb mRpCb vb vb pfet_03v3 ad=0.42p pd=2.84u as=0.42p ps=2.84u w=0.42u l=1u
X32 vbt enb VDD VDD pfet_03v3 ad=1p pd=4u as=0.45p ps=2.9u w=1u l=0.28u
X33 cb gcn ct VSS nfet_03v3 ad=1p pd=3u as=1p ps=3u w=2u l=0.5u
X34 tL glp ln VSS nfet_03v3 ad=2p pd=5u as=4p ps=10u w=4u l=0.5u
X35 ca cb VDD VDD pfet_03v3 ad=1.7p pd=5.4u as=0.765p ps=4.3u w=1.7u l=0.5u
X36 VDD ln VSS ppolyf_u r_width=1u r_length=28.56u
X37 ct gcn cb VSS nfet_03v3 ad=1p pd=3u as=1p ps=3u w=2u l=0.5u
X38 VDD lp VSS ppolyf_u r_width=1u r_length=28.56u
X39 vgr vgr vb vb pfet_03v3 ad=4p pd=10u as=4p ps=10u w=4u l=1u
X40 lp gln tL VSS nfet_03v3 ad=2p pd=5u as=2p ps=5u w=4u l=0.5u
X41 ct gcp ca VSS nfet_03v3 ad=1p pd=3u as=2p ps=6u w=2u l=0.5u
X42 mRpLa mRpLa glp glp pfet_03v3 ad=0.42p pd=2.84u as=0.42p ps=2.84u w=0.42u l=1u
X43 ca gcp ct VSS nfet_03v3 ad=2p pd=6u as=1p ps=3u w=2u l=0.5u
X44 ca ca VDD VDD pfet_03v3 ad=1p pd=4u as=0.45p ps=2.9u w=1u l=0.5u
X45 co ca VDD VDD pfet_03v3 ad=2p pd=6u as=0.9p ps=4.9u w=2u l=0.5u
X46 tL gln lp VSS nfet_03v3 ad=2p pd=5u as=2p ps=5u w=4u l=0.5u
C0 ca nb 0.51718f
C1 gln gcn 0
C2 lp inp 0.15192f
C3 gln ln 0.9762f
C4 cb ca 1.75008f
C5 gcp VDD 1.67315f
C6 enb VDD 0.1277f
C7 gcp mRpCb 0.65172f
C8 lp tL 0.40982f
C9 inp tL 0.00244f
C10 mRpLa mRpLb 0.08501f
C11 vgr vbt 0.84123f
C12 q cq 1.46447f
C13 gcp glp 0
C14 enb glp 0.00176f
C15 cq co 1.38136f
C16 mRpLb VDD 0.03325f
C17 vbt gcn 0
C18 vgr vb 9.84229f
C19 vbt ln 0.8843f
C20 q vgr 0.1075f
C21 lp nb 0.05286f
C22 inp nb 1.6067f
C23 mRpLb glp 0.09894f
C24 gcn vb 2.48838f
C25 inn VDD 0.7383f
C26 ln vb 0.22435f
C27 q gcn 0.0493f
C28 lp cb 0.8057f
C29 nb tL 0.96547f
C30 gcn co 0.00689f
C31 mRpCa vb 2.65704f
C32 vbt ca 0.02106f
C33 inn glp 0.15026f
C34 cx VDD 0.26162f
C35 q mRpCa 0.062f
C36 lp gln 4.14396f
C37 gln inp 0.30002f
C38 vgr gcp 1.70144f
C39 mRpLa VDD 0.23785f
C40 q ca 0.0045f
C41 ct gcn 1.15064f
C42 ct ln 0.12331f
C43 ca co 0.34422f
C44 gcp gcn 1.5058f
C45 gln tL 0.69379f
C46 mRpLa glp 2.67965f
C47 gcn enb 0.00683f
C48 gcp ln 2.31943f
C49 VDD mRpCb 0.28387f
C50 vgr mRpLb 1.38046f
C51 enb ln 0.10666f
C52 cb nb 0.10584f
C53 gcp mRpCa 0.49639f
C54 VDD glp 1.0466f
C55 lp vbt 0.14942f
C56 inp vbt 0.42431f
C57 ct ca 0.37966f
C58 cx cq 0
C59 vgr inn 0.03485f
C60 gln nb 0.08015f
C61 gcp ca 1.65407f
C62 ca enb 0.01232f
C63 lp vb 0.23357f
C64 inn ln 0.93344f
C65 cq VDD 0.3678f
C66 vgr mRpLa 0.17634f
C67 cx gcn 0.01262f
C68 vbt nb 0.13617f
C69 vgr VDD 2.06068f
C70 mRpLa ln 0.05539f
C71 lp ct 0.00147f
C72 vgr mRpCb 0.0027f
C73 lp gcp 2.05057f
C74 cb vbt 0.00161f
C75 gcn VDD 1.88779f
C76 inp enb 0.07276f
C77 lp enb 0.05f
C78 vgr glp 1.30234f
C79 ln VDD 1.61359f
C80 cx ca 0.19535f
C81 gcn mRpCb 1.63858f
C82 mRpCa VDD 0.22931f
C83 gln vbt 0.36652f
C84 q cb 0
C85 mRpCa mRpCb 0.1012f
C86 ln glp 2.65861f
C87 cb co 0
C88 ca VDD 0.90655f
C89 gln vb 2.67169f
C90 ct nb 1.42544f
C91 inn inp 0.31251f
C92 lp inn 0.18871f
C93 gcp nb 0.47167f
C94 enb nb 0.34739f
C95 ct cb 0.22508f
C96 cq gcn 0
C97 inn tL 0.77998f
C98 cb gcp 0.40538f
C99 cb enb 0.00427f
C100 vgr gcn 1.26016f
C101 vbt vb 0.93601f
C102 vgr ln 2.78384f
C103 gln gcp 0
C104 gln enb 0.01156f
C105 lp VDD 1.64949f
C106 inp VDD 0.53555f
C107 inn nb 0.24618f
C108 cq ca 0
C109 vgr mRpCa 0.15627f
C110 gcn ln 4.21825f
C111 q vb 0.81306f
C112 gln mRpLb 0.55439f
C113 gcn mRpCa 0.42828f
C114 lp glp 0.74193f
C115 inp glp 2.08264f
C116 tL VDD 0.1532f
C117 q co 0.02598f
C118 cx cb 0.17701f
C119 ca gcn 3.24009f
C120 vbt gcp 0.00317f
C121 inn gln 2.16324f
C122 tL glp 0.67186f
C123 ca ln 0.33477f
C124 vbt enb 0.99337f
C125 nb VDD 0.15154f
C126 gcp vb 0.79633f
C127 q gcp 0.05927f
C128 cb VDD 1.08813f
C129 nb glp 0.10638f
C130 gln mRpLa 0.1297f
C131 vgr lp 0.18006f
C132 vgr inp 0.27163f
C133 mRpLb vb 0.70349f
C134 gln VDD 1.67491f
C135 lp gcn 0.00441f
C136 ct gcp 1.49061f
C137 lp ln 0.86658f
C138 inp ln 0.46647f
C139 ct enb 0.06023f
C140 gln glp 0.84179f
C141 gcp enb 0.00724f
C142 vbt mRpLa 0.06822f
C143 ln tL 0.51679f
C144 cq cb 0
C145 q cx 0.00495f
C146 vgr nb 0.09488f
C147 lp ca 0.94964f
C148 vbt VDD 0.67795f
C149 mRpLa vb 0.99437f
C150 cx co 0.30108f
C151 gcn nb 0.25069f
C152 nb ln 0.22789f
C153 vb VDD 5.17787f
C154 vbt glp 0.86401f
C155 vb mRpCb 0.45824f
C156 q VDD 1.28185f
C157 cb gcn 2.07261f
C158 co VDD 0.40417f
C159 cb ln 0.24663f
C160 vgr gln 2.33978f
C161 vb glp 3.11f
C162 cx gcp 0
C163 nb VSS 12.9849f
C164 q VSS 3.07307f
C165 enb VSS 1.1558f
C166 inp VSS 23.2274f
C167 inn VSS 24.201f
C168 VDD VSS 94.6475f
C169 ct VSS 0.76041f
C170 tL VSS 0.74497f
C171 co VSS 0.93287f
C172 cx VSS 1.22685f
C173 ca VSS 2.16345f
C174 cb VSS 1.4863f
C175 cq VSS 0.85781f
C176 mRpCb VSS 1.49266f
C177 mRpCa VSS 0.90894f
C178 mRpLb VSS 1.62302f
C179 mRpLa VSS 0.73025f
C180 vgr VSS 7.37228f
C181 vbt VSS 1.06713f
C182 ln VSS 26.4717f
C183 lp VSS 23.7751f
C184 gcn VSS 4.96001f
C185 gcp VSS 6.66569f
C186 gln VSS 4.42568f
C187 glp VSS 3.93448f
C188 vb VSS 64.419f
.ends
