* rx_lobuf: magic R+C extraction of layout/rx_lobuf.gds (layout/gen/pex.sh)
* extracted 2026-11-16T12:08:58+01:00 with magic 8.3.642, mode c, from rx_lobuf.gds
.subckt rx_lobuf VDD VSS in en lo lob
X0 t x VDD VDD pfet_03v3 ad=1.05p pd=4.1u as=1.05p ps=4.1u w=1.05u l=0.28u
X1 lob Ny2 VSS VSS nfet_03v3 ad=1.25p pd=3.5u as=2.5p ps=7u w=2.5u l=0.28u
X2 Ny2 Ny1 VDD VDD pfet_03v3 ad=1.25p pd=3.5u as=2.5p ps=7u w=2.5u l=0.28u
X3 a b VDD VDD pfet_03v3 ad=1.05p pd=4.1u as=1.05p ps=4.1u w=1.05u l=0.28u
X4 VSS Py2 lo VSS nfet_03v3 ad=2.5p pd=7u as=1.25p ps=3.5u w=2.5u l=0.28u
X5 VDD Ny0 Ny1 VDD pfet_03v3 ad=2p pd=6u as=2p ps=6u w=2u l=0.28u
X6 Py0 a VDD VDD pfet_03v3 ad=0.625p pd=2.25u as=1.25p ps=4.5u w=1.25u l=0.28u
X7 VDD b Ny0 VDD pfet_03v3 ad=1.25p pd=4.5u as=0.625p ps=2.25u w=1.25u l=0.28u
X8 tb t VDD VDD pfet_03v3 ad=3.75p pd=9.5u as=3.75p ps=9.5u w=3.75u l=0.28u
X9 a ta VSS VSS nfet_03v3 ad=1p pd=4u as=1p ps=4u w=1u l=0.28u
X10 b VSS tb VDD pfet_03v3 ad=2.5p pd=7u as=2.5p ps=7u w=2.5u l=0.28u
X11 x in VDD VDD pfet_03v3 ad=0.3p pd=1.6u as=0.6p ps=3.2u w=0.6u l=0.28u
X12 lo Py2 VDD VDD pfet_03v3 ad=4.165p pd=10.33u as=2.0825p ps=5.165u w=4.165u l=0.28u
X13 b VDD tb VSS nfet_03v3 ad=1p pd=4u as=1p ps=4u w=1u l=0.28u
X14 VDD en Py0 VDD pfet_03v3 ad=1.25p pd=4.5u as=0.625p ps=2.25u w=1.25u l=0.28u
X15 a b VSS VSS nfet_03v3 ad=0.42p pd=2.84u as=0.42p ps=2.84u w=0.42u l=0.28u
X16 b a VSS VSS nfet_03v3 ad=0.42p pd=2.84u as=0.42p ps=2.84u w=0.42u l=0.28u
X17 Py2 Py1 VDD VDD pfet_03v3 ad=1.25p pd=3.5u as=2.5p ps=7u w=2.5u l=0.28u
X18 VDD Py2 lo VDD pfet_03v3 ad=2.0825p pd=5.165u as=2.0825p ps=5.165u w=4.165u l=0.28u
X19 Py2 Py1 VSS VSS nfet_03v3 ad=2p pd=6u as=2p ps=6u w=2u l=0.28u
X20 Py1 Py0 VDD VDD pfet_03v3 ad=2p pd=6u as=2p ps=6u w=2u l=0.28u
X21 VSS Ny2 lob VSS nfet_03v3 ad=2.5p pd=7u as=1.25p ps=3.5u w=2.5u l=0.28u
X22 VSS en Pgs VSS nfet_03v3 ad=1p pd=4u as=0.28p ps=1.56u w=1u l=0.28u
X23 Ny0 b Ngs VSS nfet_03v3 ad=1p pd=4u as=0.28p ps=1.56u w=1u l=0.28u
X24 VSS en g0s VSS nfet_03v3 ad=0.5p pd=3u as=0.14p ps=1.06u w=0.5u l=0.28u
X25 tb t VSS VSS nfet_03v3 ad=1.5p pd=5u as=1.5p ps=5u w=1.5u l=0.28u
X26 Py1 Py0 VSS VSS nfet_03v3 ad=0.8p pd=3.6u as=0.8p ps=3.6u w=0.8u l=0.28u
X27 t x VSS VSS nfet_03v3 ad=0.42p pd=2.84u as=0.42p ps=2.84u w=0.42u l=0.28u
X28 VDD Ny2 lob VDD pfet_03v3 ad=2.0825p pd=5.165u as=4.165p ps=10.33u w=4.165u l=0.28u
X29 VDD Ny2 lob VDD pfet_03v3 ad=4.165p pd=10.33u as=2.0825p ps=5.165u w=4.165u l=0.28u
X30 Ny0 en VDD VDD pfet_03v3 ad=0.625p pd=2.25u as=1.25p ps=4.5u w=1.25u l=0.28u
X31 VSS Ny1 Ny2 VSS nfet_03v3 ad=2p pd=6u as=2p ps=6u w=2u l=0.28u
X32 Pgs a Py0 VSS nfet_03v3 ad=0.28p pd=1.56u as=1p ps=4u w=1u l=0.28u
X33 VDD en x VDD pfet_03v3 ad=0.6p pd=3.2u as=0.3p ps=1.6u w=0.6u l=0.28u
X34 VSS Ny0 Ny1 VSS nfet_03v3 ad=0.8p pd=3.6u as=0.8p ps=3.6u w=0.8u l=0.28u
X35 ta t VDD VDD pfet_03v3 ad=1.25p pd=4.5u as=1.25p ps=4.5u w=1.25u l=0.28u
X36 a ta VDD VDD pfet_03v3 ad=2.5p pd=7u as=2.5p ps=7u w=2.5u l=0.28u
X37 VDD Ny1 Ny2 VDD pfet_03v3 ad=2.5p pd=7u as=1.25p ps=3.5u w=2.5u l=0.28u
X38 b a VDD VDD pfet_03v3 ad=1.05p pd=4.1u as=1.05p ps=4.1u w=1.05u l=0.28u
X39 lob Ny2 VDD VDD pfet_03v3 ad=2.0825p pd=5.165u as=2.0825p ps=5.165u w=4.165u l=0.28u
X40 VDD Py1 Py2 VDD pfet_03v3 ad=2.5p pd=7u as=1.25p ps=3.5u w=2.5u l=0.28u
X41 ta t VSS VSS nfet_03v3 ad=0.5p pd=3u as=0.5p ps=3u w=0.5u l=0.28u
X42 lo Py2 VSS VSS nfet_03v3 ad=1.25p pd=3.5u as=2.5p ps=7u w=2.5u l=0.28u
X43 lo Py2 VDD VDD pfet_03v3 ad=2.0825p pd=5.165u as=4.165p ps=10.33u w=4.165u l=0.28u
X44 Ngs en VSS VSS nfet_03v3 ad=0.28p pd=1.56u as=1p ps=4u w=1u l=0.28u
X45 g0s in x VSS nfet_03v3 ad=0.14p pd=1.06u as=0.5p ps=3u w=0.5u l=0.28u
C0 Py1 a 0
C1 ta lob 0.08215f
C2 Pgs en 0.00905f
C3 VDD en 0.6281f
C4 Pgs Py0 0.07271f
C5 VDD Py0 0.44294f
C6 g0s x 0.03739f
C7 Ny1 Ny0 1.27426f
C8 VDD b 1.522f
C9 VDD Py2 0.84771f
C10 t VDD 0.58891f
C11 in ta 0.05564f
C12 lob en 0.08076f
C13 lob Py0 0.00184f
C14 VDD Ny0 0.36888f
C15 Ny1 VDD 0.58929f
C16 lob b 0.26716f
C17 t lob 0.11325f
C18 lo a 0.44766f
C19 in en 1.02618f
C20 ta x 0.00503f
C21 in Py0 0.0923f
C22 lob Ny0 0.5145f
C23 in b 1.6034f
C24 Ny1 lob 0.20682f
C25 Pgs VDD 0
C26 in Py2 0.67175f
C27 in t 0.08591f
C28 x en 0.54597f
C29 VDD lob 0.98205f
C30 x b 0.06191f
C31 t x 1.77867f
C32 Py1 en 0.09661f
C33 in Pgs 0.00248f
C34 Py1 Py0 1.27643f
C35 in VDD 0.13872f
C36 Py1 b 0
C37 Ny2 en 0
C38 Py1 Py2 2.44938f
C39 Ngs en 0.00905f
C40 lo ta 0.11676f
C41 in lob 1.04827f
C42 Ngs b 0.00888f
C43 ta a 1.27965f
C44 VDD x 0.38477f
C45 Ny0 Ny2 0.00506f
C46 Ny1 Ny2 2.32672f
C47 lo en 2.23213f
C48 Ngs Ny0 0.07147f
C49 lo Py0 0.515f
C50 tb en 0.06062f
C51 Py1 VDD 0.5659f
C52 lo b 0.11767f
C53 x lob 0.08157f
C54 a en 0.55078f
C55 lo Py2 3.2581f
C56 tb b 0.80645f
C57 a Py0 1.44346f
C58 lo t 0.0177f
C59 VDD Ny2 0.87593f
C60 a b 2.84076f
C61 t tb 1.34876f
C62 a Py2 0
C63 Ngs VDD 0.00217f
C64 t a 0
C65 in x 1.38153f
C66 tb Ny0 0.06857f
C67 lob Ny2 4.35651f
C68 g0s en 0.00471f
C69 Ngs lob 0.00392f
C70 g0s b 0
C71 in Py1 0.44552f
C72 lo Pgs 0
C73 lo VDD 1.11959f
C74 g0s t 0
C75 VDD tb 1.55451f
C76 Pgs a 0.00896f
C77 VDD a 0.98223f
C78 lo lob 0.4029f
C79 tb lob 0.48724f
C80 ta en 0.1424f
C81 lob a 0.06283f
C82 ta b 0.06137f
C83 g0s VDD 0
C84 in lo 0.08818f
C85 ta t 1.27118f
C86 in tb 0.03717f
C87 in a 0.14537f
C88 en Py0 0.56361f
C89 en b 2.94909f
C90 g0s lob 0.00261f
C91 en Py2 0.67295f
C92 Py0 b 0.17687f
C93 Py0 Py2 0
C94 lo x 0.00185f
C95 t en 1.04578f
C96 x tb 0.17958f
C97 t b 0.21425f
C98 x a 0
C99 ta VDD 0.39422f
C100 Ny0 en 0.81999f
C101 in g0s 0.00494f
C102 Ny1 en 0.00102f
C103 Ny0 b 1.41643f
C104 lo Py1 0.12532f
C105 Ny1 b 0.00411f
C106 lo VSS 1.65422f
C107 in VSS 1.1945f
C108 en VSS 2.08155f
C109 lob VSS 2.79276f
C110 VDD VSS 61.97311f
C111 Pgs VSS 0.10589f
C112 g0s VSS 0.06752f
C113 Ngs VSS 0.10696f
C114 Py0 VSS 0.79497f
C115 a VSS 1.53102f
C116 x VSS 0.76205f
C117 Py1 VSS 1.17546f
C118 ta VSS 0.79034f
C119 b VSS 2.08213f
C120 Ny0 VSS 0.84821f
C121 tb VSS 1.17359f
C122 Ny1 VSS 1.11824f
C123 t VSS 1.28965f
C124 Py2 VSS 1.58236f
C125 Ny2 VSS 1.67581f
.ends
