* rx_lim: magic R+C extraction of layout/rx_lim.gds (layout/gen/pex.sh)
* rcfix.py: split-net C to VSS scaled by (S - K) / S on 6 nets (coupling double count removed)
* extracted 2026-11-16T12:09:02+01:00 with magic 8.3.642, mode rc, from rx_lim.gds
.subckt rx_lim VDD VSS inp inn q nb enb
X0 ct nb.t0 VSS.t26 VSS.t25 nfet_03v3 ad=2p pd=6u as=0.9p ps=4.9u w=2u l=0.5u
X1 gcn vgr vb vb pfet_03v3 ad=0.42p pd=2.84u as=0.42p ps=2.84u w=0.42u l=12u
X2 inp.t1 glp inp.t1 inp.t0 pfet_03v3 ad=12.285p pd=26.57u as=0 ps=0 w=12.285u l=10u
X3 ln gcn ln ln pfet_03v3 ad=12.285p pd=26.57u as=24.57p ps=53.14u w=12.285u l=10u
X4 VSS.t15 vb VSS.t15 VSS.t14 nfet_03v3 ad=12.285p pd=26.57u as=0 ps=0 w=12.285u l=10u
X5 mRpLa mRpLa vb vb pfet_03v3 ad=0.42p pd=2.84u as=0.42p ps=2.84u w=0.42u l=1u
X6 ln glp tL VSS.t4 nfet_03v3 ad=4p pd=10u as=2p ps=5u w=4u l=0.5u
X7 cb cb VDD.t17 VDD.t16 pfet_03v3 ad=1p pd=4u as=0.45p ps=2.9u w=1u l=0.5u
X8 cq co VSS.t28 VSS.t27 nfet_03v3 ad=0.5p pd=3u as=0.225p ps=1.9u w=0.5u l=0.28u
X9 cx cb VDD.t13 VDD.t12 pfet_03v3 ad=2p pd=6u as=0.9p ps=4.9u w=2u l=0.5u
X10 cx cx VSS.t11 VSS.t10 nfet_03v3 ad=1p pd=4u as=0.45p ps=2.9u w=1u l=0.5u
X11 co cx VSS.t13 VSS.t12 nfet_03v3 ad=1p pd=4u as=0.45p ps=2.9u w=1u l=0.5u
X12 vb vbt VSS.t2 ppolyf_u_1k r_width=1u r_length=0.15m
X13 q.t0 cq VDD.t2 VDD.t1 pfet_03v3 ad=5p pd=12u as=2.25p ps=10.9u w=5u l=0.28u
X14 cb ca VDD.t9 VDD.t8 pfet_03v3 ad=1.7p pd=5.4u as=0.765p ps=4.3u w=1.7u l=0.5u
X15 lp gcp lp lp pfet_03v3 ad=12.285p pd=26.57u as=24.57p ps=53.14u w=12.285u l=10u
X16 tL nb.t2 VSS.t24 VSS.t23 nfet_03v3 ad=2p pd=6u as=0.9p ps=4.9u w=2u l=0.5u
X17 q.t1 cq VSS.t9 VSS.t8 nfet_03v3 ad=2p pd=6u as=0.9p ps=4.9u w=2u l=0.28u
X18 VSS.t17 vb VSS.t17 VSS.t16 nfet_03v3 ad=6.1425p pd=13.285u as=0 ps=0 w=12.285u l=10u
X19 VSS.t22 nb.t1 vgr VSS.t21 nfet_03v3 ad=0.189p pd=1.74u as=0.42p ps=2.84u w=0.42u l=50u
X20 cq co VDD.t11 VDD.t10 pfet_03v3 ad=1.25p pd=4.5u as=0.5625p ps=3.4u w=1.25u l=0.28u
X21 mRpCa mRpCa vb vb pfet_03v3 ad=0.42p pd=2.84u as=0.42p ps=2.84u w=0.42u l=1u
X22 inn.t1 gln inn.t1 inn.t0 pfet_03v3 ad=12.285p pd=26.57u as=0 ps=0 w=12.285u l=10u
X23 mRpCa mRpCa gcp gcp pfet_03v3 ad=0.42p pd=2.84u as=0.42p ps=2.84u w=0.42u l=1u
X24 mRpLb mRpLb vb vb pfet_03v3 ad=0.42p pd=2.84u as=0.42p ps=2.84u w=0.42u l=1u
X25 gcp vgr vb vb pfet_03v3 ad=0.42p pd=2.84u as=0.42p ps=2.84u w=0.42u l=12u
X26 mRpCb mRpCb gcn gcn pfet_03v3 ad=0.42p pd=2.84u as=0.42p ps=2.84u w=0.42u l=1u
X27 glp vgr vb vb pfet_03v3 ad=0.42p pd=2.84u as=0.42p ps=2.84u w=0.42u l=12u
X28 gln vgr vb vb pfet_03v3 ad=0.42p pd=2.84u as=0.42p ps=2.84u w=0.42u l=12u
X29 mRpLb mRpLb gln gln pfet_03v3 ad=0.42p pd=2.84u as=0.42p ps=2.84u w=0.42u l=1u
X30 VSS.t6 vb VSS.t5 ppolyf_u_1k r_width=1u r_length=0.10002m
X31 mRpCb mRpCb vb vb pfet_03v3 ad=0.42p pd=2.84u as=0.42p ps=2.84u w=0.42u l=1u
X32 vbt enb.t0 VDD.t19 VDD.t18 pfet_03v3 ad=1p pd=4u as=0.45p ps=2.9u w=1u l=0.28u
X33 cb gcn ct VSS.t29 nfet_03v3 ad=1p pd=3u as=1p ps=3u w=2u l=0.5u
X34 tL glp ln VSS.t3 nfet_03v3 ad=2p pd=5u as=4p ps=10u w=4u l=0.5u
X35 ca cb VDD.t15 VDD.t14 pfet_03v3 ad=1.7p pd=5.4u as=0.765p ps=4.3u w=1.7u l=0.5u
X36 VDD.t3 ln VSS.t18 ppolyf_u r_width=1u r_length=28.56u
X37 ct gcn cb VSS.t30 nfet_03v3 ad=1p pd=3u as=1p ps=3u w=2u l=0.5u
X38 VDD.t0 lp VSS.t7 ppolyf_u r_width=1u r_length=28.56u
X39 vgr vgr vb vb pfet_03v3 ad=4p pd=10u as=4p ps=10u w=4u l=1u
X40 lp gln tL VSS.t0 nfet_03v3 ad=2p pd=5u as=2p ps=5u w=4u l=0.5u
X41 ct gcp ca VSS.t19 nfet_03v3 ad=1p pd=3u as=2p ps=6u w=2u l=0.5u
X42 mRpLa mRpLa glp glp pfet_03v3 ad=0.42p pd=2.84u as=0.42p ps=2.84u w=0.42u l=1u
X43 ca gcp ct VSS.t20 nfet_03v3 ad=2p pd=6u as=1p ps=3u w=2u l=0.5u
X44 ca ca VDD.t5 VDD.t4 pfet_03v3 ad=1p pd=4u as=0.45p ps=2.9u w=1u l=0.5u
X45 co ca VDD.t7 VDD.t6 pfet_03v3 ad=2p pd=6u as=0.9p ps=4.9u w=2u l=0.5u
X46 tL gln lp VSS.t1 nfet_03v3 ad=2p pd=5u as=2p ps=5u w=4u l=0.5u
R0 nb.n1 nb.t2 38.9489
R1 nb.n0 nb.t0 34.3258
R2 nb.n0 nb.t1 15.2653
R3 nb nb.n1 6.48287
R4 nb nb.n0 2.81892
R5 nb.n1 nb 0.0644474
R6 q q.n0 21.0226
R7 q.n0 q.t1 3.74734
R8 q.n0 q.t0 3.20879
R9 enb enb.t0 37.3349
R10 inp.n0 inp.t0 519.854
R11 inp.n1 inp.t1 8.7358
R12 inp.n0 inp.t1 7.67474
R13 inp inp.n1 6.64392
R14 inp inp.n0 1.15037
R15 inp.n1 inp 0.394842
R16 inn.n0 inn.t0 519.692
R17 inn.n1 inn.t1 8.91106
R18 inn.n0 inn.t1 7.51369
R19 inn inn.n1 6.80497
R20 inn inn.n0 1.15037
R21 inn.n1 inn 0.0585263
R22 VDD.n84 VDD.t18 21681
R23 VDD.n84 VDD.t4 6709.24
R24 VDD.t16 VDD.t12 170.649
R25 VDD.t12 VDD.t6 158.238
R26 VDD.t8 VDD.t16 158.238
R27 VDD.t14 VDD.t8 158.238
R28 VDD.t4 VDD.t14 158.238
R29 VDD.t6 VDD.t10 151.412
R30 VDD.t10 VDD.t1 144.587
R31 VDD.n0 VDD.t0 13.9154
R32 VDD.n0 VDD.t3 11.9496
R33 VDD.n1 VDD.n0 11.3275
R34 VDD.n118 VDD.t19 7.57826
R35 VDD.n67 VDD.t5 7.57826
R36 VDD.n59 VDD.t17 7.57826
R37 VDD.n41 VDD.t11 7.17766
R38 VDD.n35 VDD.t15 5.86488
R39 VDD.n61 VDD.t9 5.86488
R40 VDD.n37 VDD.t13 5.23234
R41 VDD.n50 VDD.t7 5.23234
R42 VDD.n44 VDD.t2 3.54058
R43 VDD.n129 VDD.n4 1.5755
R44 VDD.n137 VDD.n136 1.5755
R45 VDD.n64 VDD.n33 1.5755
R46 VDD.n114 VDD.n113 1.5755
R47 VDD.n46 VDD.n45 1.5755
R48 VDD.n56 VDD.n55 1.5755
R49 VDD.n121 VDD.n9 1.50139
R50 VDD.n47 VDD.n46 1.5005
R51 VDD.n40 VDD.n39 1.5005
R52 VDD.n55 VDD.n54 1.5005
R53 VDD.n34 VDD.n33 1.5005
R54 VDD.n71 VDD.n70 1.5005
R55 VDD.n73 VDD.n72 1.5005
R56 VDD.n30 VDD.n29 1.5005
R57 VDD.n79 VDD.n78 1.5005
R58 VDD.n81 VDD.n80 1.5005
R59 VDD.n26 VDD.n25 1.5005
R60 VDD.n89 VDD.n88 1.5005
R61 VDD.n91 VDD.n90 1.5005
R62 VDD.n22 VDD.n21 1.5005
R63 VDD.n97 VDD.n96 1.5005
R64 VDD.n99 VDD.n98 1.5005
R65 VDD.n18 VDD.n17 1.5005
R66 VDD.n105 VDD.n104 1.5005
R67 VDD.n107 VDD.n106 1.5005
R68 VDD.n14 VDD.n13 1.5005
R69 VDD.n113 VDD.n112 1.5005
R70 VDD.n5 VDD.n4 1.5005
R71 VDD.n136 VDD.n135 1.5005
R72 VDD.n43 VDD.n42 1.5005
R73 VDD.n49 VDD.n48 1.5005
R74 VDD.n53 VDD.n52 1.5005
R75 VDD.n51 VDD.n38 1.5005
R76 VDD.n58 VDD.n57 1.5005
R77 VDD.n60 VDD.n36 1.5005
R78 VDD.n63 VDD.n62 1.5005
R79 VDD.n66 VDD.n65 1.5005
R80 VDD.n69 VDD.n68 1.5005
R81 VDD.n32 VDD.n31 1.5005
R82 VDD.n75 VDD.n74 1.5005
R83 VDD.n77 VDD.n76 1.5005
R84 VDD.n28 VDD.n27 1.5005
R85 VDD.n83 VDD.n82 1.5005
R86 VDD.n87 VDD.n86 1.5005
R87 VDD.n24 VDD.n23 1.5005
R88 VDD.n93 VDD.n92 1.5005
R89 VDD.n95 VDD.n94 1.5005
R90 VDD.n20 VDD.n19 1.5005
R91 VDD.n101 VDD.n100 1.5005
R92 VDD.n103 VDD.n102 1.5005
R93 VDD.n16 VDD.n15 1.5005
R94 VDD.n109 VDD.n108 1.5005
R95 VDD.n111 VDD.n110 1.5005
R96 VDD.n12 VDD.n11 1.5005
R97 VDD.n116 VDD.n115 1.5005
R98 VDD.n117 VDD.n10 1.5005
R99 VDD.n120 VDD.n119 1.5005
R100 VDD.n122 VDD.n8 1.5005
R101 VDD.n124 VDD.n123 1.5005
R102 VDD.n125 VDD.n7 1.5005
R103 VDD.n127 VDD.n126 1.5005
R104 VDD.n128 VDD.n6 1.5005
R105 VDD.n131 VDD.n130 1.5005
R106 VDD.n134 VDD.n133 1.5005
R107 VDD.n132 VDD.n3 1.5005
R108 VDD.n138 VDD.n2 1.5005
R109 VDD.n140 VDD.n139 1.5005
R110 VDD.n141 VDD.n140 0.473314
R111 VDD.n45 VDD.n44 0.462242
R112 VDD.n141 VDD.n1 0.13081
R113 VDD VDD.n141 0.100472
R114 VDD.n136 VDD.n4 0.0755
R115 VDD.n71 VDD.n33 0.0755
R116 VDD.n72 VDD.n71 0.0755
R117 VDD.n72 VDD.n29 0.0755
R118 VDD.n79 VDD.n29 0.0755
R119 VDD.n80 VDD.n79 0.0755
R120 VDD.n80 VDD.n25 0.0755
R121 VDD.n89 VDD.n25 0.0755
R122 VDD.n90 VDD.n89 0.0755
R123 VDD.n90 VDD.n21 0.0755
R124 VDD.n97 VDD.n21 0.0755
R125 VDD.n98 VDD.n97 0.0755
R126 VDD.n98 VDD.n17 0.0755
R127 VDD.n105 VDD.n17 0.0755
R128 VDD.n106 VDD.n105 0.0755
R129 VDD.n106 VDD.n13 0.0755
R130 VDD.n113 VDD.n13 0.0755
R131 VDD.n46 VDD.n39 0.0755
R132 VDD.n55 VDD.n39 0.0755
R133 VDD.n52 VDD.n51 0.0755
R134 VDD.n68 VDD.n66 0.0755
R135 VDD.n75 VDD.n31 0.0755
R136 VDD.n76 VDD.n75 0.0755
R137 VDD.n76 VDD.n27 0.0755
R138 VDD.n83 VDD.n27 0.0755
R139 VDD.n86 VDD.n23 0.0755
R140 VDD.n93 VDD.n23 0.0755
R141 VDD.n94 VDD.n93 0.0755
R142 VDD.n94 VDD.n19 0.0755
R143 VDD.n101 VDD.n19 0.0755
R144 VDD.n102 VDD.n101 0.0755
R145 VDD.n102 VDD.n15 0.0755
R146 VDD.n109 VDD.n15 0.0755
R147 VDD.n110 VDD.n109 0.0755
R148 VDD.n110 VDD.n11 0.0755
R149 VDD.n116 VDD.n11 0.0755
R150 VDD.n117 VDD.n116 0.0755
R151 VDD.n119 VDD.n9 0.0755
R152 VDD.n9 VDD.n8 0.0755
R153 VDD.n124 VDD.n8 0.0755
R154 VDD.n125 VDD.n124 0.0755
R155 VDD.n126 VDD.n125 0.0755
R156 VDD.n126 VDD.n6 0.0755
R157 VDD.n131 VDD.n6 0.0755
R158 VDD.n133 VDD.n131 0.0755
R159 VDD.n133 VDD.n132 0.0755
R160 VDD.n132 VDD.n2 0.0755
R161 VDD.n140 VDD.n2 0.0755
R162 VDD.n57 VDD.n36 0.0755
R163 VDD.n63 VDD.n36 0.0755
R164 VDD.n115 VDD.n10 0.0755
R165 VDD.n120 VDD.n10 0.0755
R166 VDD.n123 VDD.n122 0.0755
R167 VDD.n123 VDD.n7 0.0755
R168 VDD.n127 VDD.n7 0.0755
R169 VDD.n128 VDD.n127 0.0755
R170 VDD.n139 VDD.n138 0.0755
R171 VDD.n121 VDD.n120 0.0754286
R172 VDD.n122 VDD.n121 0.0747857
R173 VDD.n58 VDD.n37 0.0730625
R174 VDD.n62 VDD.n35 0.0723125
R175 VDD.n64 VDD.n63 0.071
R176 VDD.n65 VDD.n34 0.071
R177 VDD.n70 VDD.n69 0.071
R178 VDD.n73 VDD.n32 0.071
R179 VDD.n74 VDD.n30 0.071
R180 VDD.n78 VDD.n77 0.071
R181 VDD.n81 VDD.n28 0.071
R182 VDD.n82 VDD.n26 0.071
R183 VDD.n88 VDD.n87 0.071
R184 VDD.n91 VDD.n24 0.071
R185 VDD.n92 VDD.n22 0.071
R186 VDD.n96 VDD.n95 0.071
R187 VDD.n99 VDD.n20 0.071
R188 VDD.n100 VDD.n18 0.071
R189 VDD.n104 VDD.n103 0.071
R190 VDD.n107 VDD.n16 0.071
R191 VDD.n108 VDD.n14 0.071
R192 VDD.n112 VDD.n111 0.071
R193 VDD.n114 VDD.n12 0.071
R194 VDD.n119 VDD.n118 0.0696875
R195 VDD.n129 VDD.n128 0.0635
R196 VDD.n130 VDD.n5 0.0635
R197 VDD.n135 VDD.n134 0.0635
R198 VDD.n137 VDD.n3 0.0635
R199 VDD.n67 VDD.n31 0.0580625
R200 VDD.n50 VDD.n49 0.0573125
R201 VDD.n86 VDD.n85 0.055625
R202 VDD.n85 VDD.n84 0.0519286
R203 VDD.n44 VDD.n43 0.0516875
R204 VDD.n61 VDD.n60 0.0516875
R205 VDD.n60 VDD.n59 0.0449375
R206 VDD.n47 VDD.n42 0.0395
R207 VDD.n48 VDD.n40 0.0395
R208 VDD.n54 VDD.n53 0.0395
R209 VDD.n56 VDD.n38 0.0395
R210 VDD.n49 VDD.n41 0.0393125
R211 VDD.n139 VDD.n1 0.0381875
R212 VDD.n43 VDD.n41 0.0366875
R213 VDD.n45 VDD.n42 0.0365
R214 VDD.n48 VDD.n47 0.0365
R215 VDD.n53 VDD.n40 0.0365
R216 VDD.n54 VDD.n38 0.0365
R217 VDD.n57 VDD.n56 0.0365
R218 VDD.n59 VDD.n58 0.0310625
R219 VDD.n62 VDD.n61 0.0243125
R220 VDD.n85 VDD.n83 0.020375
R221 VDD.n52 VDD.n50 0.0186875
R222 VDD.n68 VDD.n67 0.0179375
R223 VDD.n130 VDD.n129 0.0125
R224 VDD.n134 VDD.n5 0.0125
R225 VDD.n135 VDD.n3 0.0125
R226 VDD.n138 VDD.n137 0.0125
R227 VDD.n118 VDD.n117 0.0063125
R228 VDD.n65 VDD.n64 0.005
R229 VDD.n69 VDD.n34 0.005
R230 VDD.n70 VDD.n32 0.005
R231 VDD.n74 VDD.n73 0.005
R232 VDD.n77 VDD.n30 0.005
R233 VDD.n78 VDD.n28 0.005
R234 VDD.n82 VDD.n81 0.005
R235 VDD.n87 VDD.n26 0.005
R236 VDD.n88 VDD.n24 0.005
R237 VDD.n92 VDD.n91 0.005
R238 VDD.n95 VDD.n22 0.005
R239 VDD.n96 VDD.n20 0.005
R240 VDD.n100 VDD.n99 0.005
R241 VDD.n103 VDD.n18 0.005
R242 VDD.n104 VDD.n16 0.005
R243 VDD.n108 VDD.n107 0.005
R244 VDD.n111 VDD.n14 0.005
R245 VDD.n112 VDD.n12 0.005
R246 VDD.n115 VDD.n114 0.005
R247 VDD.n66 VDD.n35 0.0036875
R248 VDD.n51 VDD.n37 0.0029375
R249 VSS.n356 VSS.n41 102435
R250 VSS.n355 VSS.t23 96124.6
R251 VSS.n44 VSS.n43 94208.6
R252 VSS.n45 VSS.n42 60444.2
R253 VSS.n353 VSS.n42 57091.8
R254 VSS.n355 VSS.n354 49415.1
R255 VSS.t8 VSS.n44 37465.8
R256 VSS.t18 VSS.n356 36133.6
R257 VSS.n356 VSS.n355 31005.7
R258 VSS.n352 VSS.n42 26745.6
R259 VSS.n43 VSS.n40 4878.65
R260 VSS.n41 VSS.n40 4805.62
R261 VSS.n358 VSS.n40 3785.29
R262 VSS.n357 VSS.n41 3785.29
R263 VSS.n354 VSS.n353 3487.41
R264 VSS.n43 VSS.n39 3386.84
R265 VSS.n45 VSS.t10 2919.97
R266 VSS.n44 VSS.t16 2353.53
R267 VSS.t4 VSS.n354 2281.23
R268 VSS.n351 VSS.n45 1990.73
R269 VSS.n352 VSS.n351 1638.46
R270 VSS.t16 VSS.t14 1563.18
R271 VSS.n357 VSS.t2 1392.65
R272 VSS.t21 VSS.n352 1333
R273 VSS.t14 VSS.t5 1108.44
R274 VSS.n358 VSS.n357 935.068
R275 VSS.t25 VSS.t19 912.856
R276 VSS.t23 VSS.t3 912.856
R277 VSS.n359 VSS.n358 680.696
R278 VSS.t10 VSS.t12 596.867
R279 VSS.t12 VSS.t27 571.12
R280 VSS.t27 VSS.t8 545.374
R281 VSS.t30 VSS.t20 351.099
R282 VSS.t29 VSS.t30 351.099
R283 VSS.t19 VSS.t29 351.099
R284 VSS.t1 VSS.t4 351.099
R285 VSS.t0 VSS.t1 351.099
R286 VSS.t3 VSS.t0 351.099
R287 VSS.t20 VSS.t21 347.587
R288 VSS.t2 VSS.t7 326.848
R289 VSS.t7 VSS.t18 326.848
R290 VSS.n359 VSS.n39 268.584
R291 VSS.t5 VSS.n39 85.265
R292 VSS.n135 VSS.t6 25.8192
R293 VSS.n234 VSS.t22 11.2418
R294 VSS.n216 VSS.t28 10.6698
R295 VSS.n353 VSS.t25 5.85214
R296 VSS.n64 VSS.t13 5.79105
R297 VSS.n225 VSS.t11 5.79105
R298 VSS.n181 VSS.n180 5.6892
R299 VSS.n431 VSS.n430 5.60994
R300 VSS.n214 VSS.t9 3.26288
R301 VSS.n1 VSS.t24 3.26288
R302 VSS.n270 VSS.t26 2.7892
R303 VSS.n104 VSS.t15 2.09672
R304 VSS.n166 VSS.t17 2.09672
R305 VSS.n150 VSS.n98 1.84031
R306 VSS.n185 VSS.n82 1.5755
R307 VSS.n322 VSS.n321 1.5755
R308 VSS.n314 VSS.n272 1.5755
R309 VSS.n313 VSS.n274 1.5755
R310 VSS.n306 VSS.n305 1.5755
R311 VSS.n291 VSS.n282 1.5755
R312 VSS.n145 VSS.n100 1.5755
R313 VSS.n137 VSS.n136 1.5755
R314 VSS.n179 VSS.n178 1.5755
R315 VSS.n154 VSS.n153 1.5755
R316 VSS.n129 VSS.n106 1.5755
R317 VSS.n429 VSS.n428 1.5755
R318 VSS.n431 VSS.n1 1.52994
R319 VSS.n84 VSS.n83 1.5005
R320 VSS.n176 VSS.n175 1.5005
R321 VSS.n174 VSS.n173 1.5005
R322 VSS.n88 VSS.n87 1.5005
R323 VSS.n168 VSS.n167 1.5005
R324 VSS.n165 VSS.n164 1.5005
R325 VSS.n92 VSS.n91 1.5005
R326 VSS.n159 VSS.n158 1.5005
R327 VSS.n157 VSS.n156 1.5005
R328 VSS.n96 VSS.n95 1.5005
R329 VSS.n152 VSS.n151 1.5005
R330 VSS.n149 VSS.n97 1.5005
R331 VSS.n148 VSS.n147 1.5005
R332 VSS.n101 VSS.n99 1.5005
R333 VSS.n142 VSS.n141 1.5005
R334 VSS.n140 VSS.n139 1.5005
R335 VSS.n130 VSS.n129 1.5005
R336 VSS.n128 VSS.n127 1.5005
R337 VSS.n111 VSS.n110 1.5005
R338 VSS.n122 VSS.n121 1.5005
R339 VSS.n120 VSS.n119 1.5005
R340 VSS.n116 VSS.n114 1.5005
R341 VSS.n37 VSS.n36 1.5005
R342 VSS.n364 VSS.n363 1.5005
R343 VSS.n366 VSS.n365 1.5005
R344 VSS.n33 VSS.n32 1.5005
R345 VSS.n372 VSS.n371 1.5005
R346 VSS.n374 VSS.n373 1.5005
R347 VSS.n29 VSS.n28 1.5005
R348 VSS.n380 VSS.n379 1.5005
R349 VSS.n382 VSS.n381 1.5005
R350 VSS.n25 VSS.n24 1.5005
R351 VSS.n388 VSS.n387 1.5005
R352 VSS.n390 VSS.n389 1.5005
R353 VSS.n21 VSS.n20 1.5005
R354 VSS.n396 VSS.n395 1.5005
R355 VSS.n398 VSS.n397 1.5005
R356 VSS.n17 VSS.n16 1.5005
R357 VSS.n404 VSS.n403 1.5005
R358 VSS.n406 VSS.n405 1.5005
R359 VSS.n13 VSS.n12 1.5005
R360 VSS.n412 VSS.n411 1.5005
R361 VSS.n414 VSS.n413 1.5005
R362 VSS.n9 VSS.n8 1.5005
R363 VSS.n420 VSS.n419 1.5005
R364 VSS.n422 VSS.n421 1.5005
R365 VSS.n5 VSS.n4 1.5005
R366 VSS.n428 VSS.n427 1.5005
R367 VSS.n178 VSS.n177 1.5005
R368 VSS.n86 VSS.n85 1.5005
R369 VSS.n172 VSS.n171 1.5005
R370 VSS.n170 VSS.n169 1.5005
R371 VSS.n90 VSS.n89 1.5005
R372 VSS.n163 VSS.n162 1.5005
R373 VSS.n161 VSS.n160 1.5005
R374 VSS.n94 VSS.n93 1.5005
R375 VSS.n155 VSS.n154 1.5005
R376 VSS.n146 VSS.n145 1.5005
R377 VSS.n144 VSS.n143 1.5005
R378 VSS.n103 VSS.n102 1.5005
R379 VSS.n138 VSS.n137 1.5005
R380 VSS.n107 VSS.n105 1.5005
R381 VSS.n134 VSS.n133 1.5005
R382 VSS.n132 VSS.n131 1.5005
R383 VSS.n109 VSS.n108 1.5005
R384 VSS.n126 VSS.n125 1.5005
R385 VSS.n124 VSS.n123 1.5005
R386 VSS.n113 VSS.n112 1.5005
R387 VSS.n118 VSS.n117 1.5005
R388 VSS.n115 VSS.n38 1.5005
R389 VSS.n362 VSS.n361 1.5005
R390 VSS.n35 VSS.n34 1.5005
R391 VSS.n368 VSS.n367 1.5005
R392 VSS.n370 VSS.n369 1.5005
R393 VSS.n31 VSS.n30 1.5005
R394 VSS.n376 VSS.n375 1.5005
R395 VSS.n378 VSS.n377 1.5005
R396 VSS.n27 VSS.n26 1.5005
R397 VSS.n384 VSS.n383 1.5005
R398 VSS.n386 VSS.n385 1.5005
R399 VSS.n23 VSS.n22 1.5005
R400 VSS.n392 VSS.n391 1.5005
R401 VSS.n394 VSS.n393 1.5005
R402 VSS.n19 VSS.n18 1.5005
R403 VSS.n400 VSS.n399 1.5005
R404 VSS.n402 VSS.n401 1.5005
R405 VSS.n15 VSS.n14 1.5005
R406 VSS.n408 VSS.n407 1.5005
R407 VSS.n410 VSS.n409 1.5005
R408 VSS.n11 VSS.n10 1.5005
R409 VSS.n416 VSS.n415 1.5005
R410 VSS.n418 VSS.n417 1.5005
R411 VSS.n7 VSS.n6 1.5005
R412 VSS.n424 VSS.n423 1.5005
R413 VSS.n426 VSS.n425 1.5005
R414 VSS.n3 VSS.n2 1.5005
R415 VSS.n283 VSS.n282 1.5005
R416 VSS.n297 VSS.n296 1.5005
R417 VSS.n299 VSS.n298 1.5005
R418 VSS.n278 VSS.n277 1.5005
R419 VSS.n305 VSS.n304 1.5005
R420 VSS.n313 VSS.n312 1.5005
R421 VSS.n315 VSS.n314 1.5005
R422 VSS.n323 VSS.n322 1.5005
R423 VSS.n266 VSS.n265 1.5005
R424 VSS.n329 VSS.n328 1.5005
R425 VSS.n331 VSS.n330 1.5005
R426 VSS.n262 VSS.n261 1.5005
R427 VSS.n337 VSS.n336 1.5005
R428 VSS.n339 VSS.n338 1.5005
R429 VSS.n258 VSS.n257 1.5005
R430 VSS.n345 VSS.n344 1.5005
R431 VSS.n347 VSS.n346 1.5005
R432 VSS.n256 VSS.n48 1.5005
R433 VSS.n255 VSS.n254 1.5005
R434 VSS.n51 VSS.n50 1.5005
R435 VSS.n248 VSS.n247 1.5005
R436 VSS.n246 VSS.n245 1.5005
R437 VSS.n55 VSS.n54 1.5005
R438 VSS.n240 VSS.n239 1.5005
R439 VSS.n238 VSS.n237 1.5005
R440 VSS.n59 VSS.n58 1.5005
R441 VSS.n231 VSS.n230 1.5005
R442 VSS.n229 VSS.n228 1.5005
R443 VSS.n63 VSS.n62 1.5005
R444 VSS.n222 VSS.n221 1.5005
R445 VSS.n220 VSS.n219 1.5005
R446 VSS.n67 VSS.n66 1.5005
R447 VSS.n211 VSS.n210 1.5005
R448 VSS.n209 VSS.n208 1.5005
R449 VSS.n71 VSS.n70 1.5005
R450 VSS.n203 VSS.n202 1.5005
R451 VSS.n201 VSS.n200 1.5005
R452 VSS.n75 VSS.n74 1.5005
R453 VSS.n195 VSS.n194 1.5005
R454 VSS.n193 VSS.n192 1.5005
R455 VSS.n79 VSS.n78 1.5005
R456 VSS.n187 VSS.n186 1.5005
R457 VSS.n185 VSS.n184 1.5005
R458 VSS.n183 VSS.n182 1.5005
R459 VSS.n81 VSS.n80 1.5005
R460 VSS.n189 VSS.n188 1.5005
R461 VSS.n191 VSS.n190 1.5005
R462 VSS.n77 VSS.n76 1.5005
R463 VSS.n197 VSS.n196 1.5005
R464 VSS.n199 VSS.n198 1.5005
R465 VSS.n73 VSS.n72 1.5005
R466 VSS.n205 VSS.n204 1.5005
R467 VSS.n207 VSS.n206 1.5005
R468 VSS.n69 VSS.n68 1.5005
R469 VSS.n213 VSS.n212 1.5005
R470 VSS.n218 VSS.n217 1.5005
R471 VSS.n215 VSS.n65 1.5005
R472 VSS.n224 VSS.n223 1.5005
R473 VSS.n227 VSS.n226 1.5005
R474 VSS.n61 VSS.n60 1.5005
R475 VSS.n233 VSS.n232 1.5005
R476 VSS.n236 VSS.n235 1.5005
R477 VSS.n57 VSS.n56 1.5005
R478 VSS.n242 VSS.n241 1.5005
R479 VSS.n244 VSS.n243 1.5005
R480 VSS.n53 VSS.n52 1.5005
R481 VSS.n250 VSS.n249 1.5005
R482 VSS.n252 VSS.n251 1.5005
R483 VSS.n253 VSS.n46 1.5005
R484 VSS.n349 VSS.n348 1.5005
R485 VSS.n49 VSS.n47 1.5005
R486 VSS.n343 VSS.n342 1.5005
R487 VSS.n341 VSS.n340 1.5005
R488 VSS.n260 VSS.n259 1.5005
R489 VSS.n335 VSS.n334 1.5005
R490 VSS.n333 VSS.n332 1.5005
R491 VSS.n264 VSS.n263 1.5005
R492 VSS.n327 VSS.n326 1.5005
R493 VSS.n325 VSS.n324 1.5005
R494 VSS.n268 VSS.n267 1.5005
R495 VSS.n320 VSS.n319 1.5005
R496 VSS.n318 VSS.n269 1.5005
R497 VSS.n317 VSS.n316 1.5005
R498 VSS.n273 VSS.n271 1.5005
R499 VSS.n311 VSS.n310 1.5005
R500 VSS.n309 VSS.n308 1.5005
R501 VSS.n307 VSS.n275 1.5005
R502 VSS.n279 VSS.n276 1.5005
R503 VSS.n303 VSS.n302 1.5005
R504 VSS.n301 VSS.n300 1.5005
R505 VSS.n281 VSS.n280 1.5005
R506 VSS.n295 VSS.n294 1.5005
R507 VSS.n293 VSS.n292 1.5005
R508 VSS.n290 VSS.n284 1.5005
R509 VSS.n289 VSS.n288 1.5005
R510 VSS.n287 VSS.n285 1.5005
R511 VSS.n286 VSS.n0 1.5005
R512 VSS.n182 VSS.n181 0.592518
R513 VSS.n430 VSS.n2 0.585263
R514 VSS.n180 VSS.n83 0.474643
R515 VSS.n98 VSS.t17 0.25691
R516 VSS.t15 VSS.n98 0.25691
R517 VSS.n430 VSS.n429 0.117112
R518 VSS.n180 VSS.n179 0.0983129
R519 VSS.n181 VSS.n82 0.0806073
R520 VSS.n186 VSS.n185 0.0755
R521 VSS.n186 VSS.n78 0.0755
R522 VSS.n193 VSS.n78 0.0755
R523 VSS.n194 VSS.n193 0.0755
R524 VSS.n194 VSS.n74 0.0755
R525 VSS.n201 VSS.n74 0.0755
R526 VSS.n202 VSS.n201 0.0755
R527 VSS.n202 VSS.n70 0.0755
R528 VSS.n209 VSS.n70 0.0755
R529 VSS.n210 VSS.n209 0.0755
R530 VSS.n210 VSS.n66 0.0755
R531 VSS.n220 VSS.n66 0.0755
R532 VSS.n221 VSS.n220 0.0755
R533 VSS.n221 VSS.n62 0.0755
R534 VSS.n229 VSS.n62 0.0755
R535 VSS.n230 VSS.n229 0.0755
R536 VSS.n230 VSS.n58 0.0755
R537 VSS.n238 VSS.n58 0.0755
R538 VSS.n239 VSS.n238 0.0755
R539 VSS.n239 VSS.n54 0.0755
R540 VSS.n246 VSS.n54 0.0755
R541 VSS.n247 VSS.n246 0.0755
R542 VSS.n247 VSS.n50 0.0755
R543 VSS.n255 VSS.n50 0.0755
R544 VSS.n256 VSS.n255 0.0755
R545 VSS.n346 VSS.n256 0.0755
R546 VSS.n346 VSS.n345 0.0755
R547 VSS.n345 VSS.n257 0.0755
R548 VSS.n338 VSS.n257 0.0755
R549 VSS.n338 VSS.n337 0.0755
R550 VSS.n337 VSS.n261 0.0755
R551 VSS.n330 VSS.n261 0.0755
R552 VSS.n330 VSS.n329 0.0755
R553 VSS.n329 VSS.n265 0.0755
R554 VSS.n322 VSS.n265 0.0755
R555 VSS.n314 VSS.n313 0.0755
R556 VSS.n305 VSS.n277 0.0755
R557 VSS.n298 VSS.n277 0.0755
R558 VSS.n298 VSS.n297 0.0755
R559 VSS.n297 VSS.n282 0.0755
R560 VSS.n145 VSS.n144 0.0755
R561 VSS.n144 VSS.n102 0.0755
R562 VSS.n137 VSS.n102 0.0755
R563 VSS.n178 VSS.n85 0.0755
R564 VSS.n171 VSS.n85 0.0755
R565 VSS.n171 VSS.n170 0.0755
R566 VSS.n170 VSS.n89 0.0755
R567 VSS.n162 VSS.n89 0.0755
R568 VSS.n162 VSS.n161 0.0755
R569 VSS.n161 VSS.n93 0.0755
R570 VSS.n154 VSS.n93 0.0755
R571 VSS.n129 VSS.n128 0.0755
R572 VSS.n128 VSS.n110 0.0755
R573 VSS.n121 VSS.n110 0.0755
R574 VSS.n121 VSS.n120 0.0755
R575 VSS.n120 VSS.n114 0.0755
R576 VSS.n114 VSS.n36 0.0755
R577 VSS.n364 VSS.n36 0.0755
R578 VSS.n365 VSS.n364 0.0755
R579 VSS.n365 VSS.n32 0.0755
R580 VSS.n372 VSS.n32 0.0755
R581 VSS.n373 VSS.n372 0.0755
R582 VSS.n373 VSS.n28 0.0755
R583 VSS.n380 VSS.n28 0.0755
R584 VSS.n381 VSS.n380 0.0755
R585 VSS.n381 VSS.n24 0.0755
R586 VSS.n388 VSS.n24 0.0755
R587 VSS.n389 VSS.n388 0.0755
R588 VSS.n389 VSS.n20 0.0755
R589 VSS.n396 VSS.n20 0.0755
R590 VSS.n397 VSS.n396 0.0755
R591 VSS.n397 VSS.n16 0.0755
R592 VSS.n404 VSS.n16 0.0755
R593 VSS.n405 VSS.n404 0.0755
R594 VSS.n405 VSS.n12 0.0755
R595 VSS.n412 VSS.n12 0.0755
R596 VSS.n413 VSS.n412 0.0755
R597 VSS.n413 VSS.n8 0.0755
R598 VSS.n420 VSS.n8 0.0755
R599 VSS.n421 VSS.n420 0.0755
R600 VSS.n421 VSS.n4 0.0755
R601 VSS.n428 VSS.n4 0.0755
R602 VSS.n182 VSS.n80 0.0755
R603 VSS.n189 VSS.n80 0.0755
R604 VSS.n190 VSS.n189 0.0755
R605 VSS.n190 VSS.n76 0.0755
R606 VSS.n197 VSS.n76 0.0755
R607 VSS.n198 VSS.n197 0.0755
R608 VSS.n198 VSS.n72 0.0755
R609 VSS.n205 VSS.n72 0.0755
R610 VSS.n206 VSS.n205 0.0755
R611 VSS.n206 VSS.n68 0.0755
R612 VSS.n213 VSS.n68 0.0755
R613 VSS.n226 VSS.n224 0.0755
R614 VSS.n233 VSS.n60 0.0755
R615 VSS.n235 VSS.n233 0.0755
R616 VSS.n242 VSS.n56 0.0755
R617 VSS.n243 VSS.n242 0.0755
R618 VSS.n243 VSS.n52 0.0755
R619 VSS.n250 VSS.n52 0.0755
R620 VSS.n251 VSS.n250 0.0755
R621 VSS.n251 VSS.n46 0.0755
R622 VSS.n349 VSS.n47 0.0755
R623 VSS.n342 VSS.n47 0.0755
R624 VSS.n342 VSS.n341 0.0755
R625 VSS.n341 VSS.n259 0.0755
R626 VSS.n334 VSS.n259 0.0755
R627 VSS.n334 VSS.n333 0.0755
R628 VSS.n333 VSS.n263 0.0755
R629 VSS.n326 VSS.n263 0.0755
R630 VSS.n326 VSS.n325 0.0755
R631 VSS.n325 VSS.n267 0.0755
R632 VSS.n319 VSS.n318 0.0755
R633 VSS.n318 VSS.n317 0.0755
R634 VSS.n317 VSS.n271 0.0755
R635 VSS.n310 VSS.n271 0.0755
R636 VSS.n310 VSS.n309 0.0755
R637 VSS.n309 VSS.n275 0.0755
R638 VSS.n279 VSS.n275 0.0755
R639 VSS.n302 VSS.n279 0.0755
R640 VSS.n302 VSS.n301 0.0755
R641 VSS.n301 VSS.n280 0.0755
R642 VSS.n294 VSS.n280 0.0755
R643 VSS.n294 VSS.n293 0.0755
R644 VSS.n293 VSS.n284 0.0755
R645 VSS.n288 VSS.n284 0.0755
R646 VSS.n288 VSS.n287 0.0755
R647 VSS.n287 VSS.n286 0.0755
R648 VSS.n175 VSS.n83 0.0755
R649 VSS.n175 VSS.n174 0.0755
R650 VSS.n174 VSS.n87 0.0755
R651 VSS.n167 VSS.n87 0.0755
R652 VSS.n165 VSS.n91 0.0755
R653 VSS.n158 VSS.n91 0.0755
R654 VSS.n158 VSS.n157 0.0755
R655 VSS.n157 VSS.n95 0.0755
R656 VSS.n151 VSS.n95 0.0755
R657 VSS.n149 VSS.n148 0.0755
R658 VSS.n148 VSS.n99 0.0755
R659 VSS.n141 VSS.n99 0.0755
R660 VSS.n141 VSS.n140 0.0755
R661 VSS.n133 VSS.n107 0.0755
R662 VSS.n133 VSS.n132 0.0755
R663 VSS.n132 VSS.n108 0.0755
R664 VSS.n125 VSS.n108 0.0755
R665 VSS.n125 VSS.n124 0.0755
R666 VSS.n124 VSS.n112 0.0755
R667 VSS.n117 VSS.n112 0.0755
R668 VSS.n117 VSS.n38 0.0755
R669 VSS.n361 VSS.n34 0.0755
R670 VSS.n368 VSS.n34 0.0755
R671 VSS.n369 VSS.n368 0.0755
R672 VSS.n369 VSS.n30 0.0755
R673 VSS.n376 VSS.n30 0.0755
R674 VSS.n377 VSS.n376 0.0755
R675 VSS.n377 VSS.n26 0.0755
R676 VSS.n384 VSS.n26 0.0755
R677 VSS.n385 VSS.n384 0.0755
R678 VSS.n385 VSS.n22 0.0755
R679 VSS.n392 VSS.n22 0.0755
R680 VSS.n393 VSS.n392 0.0755
R681 VSS.n393 VSS.n18 0.0755
R682 VSS.n400 VSS.n18 0.0755
R683 VSS.n401 VSS.n400 0.0755
R684 VSS.n401 VSS.n14 0.0755
R685 VSS.n408 VSS.n14 0.0755
R686 VSS.n409 VSS.n408 0.0755
R687 VSS.n409 VSS.n10 0.0755
R688 VSS.n416 VSS.n10 0.0755
R689 VSS.n417 VSS.n416 0.0755
R690 VSS.n417 VSS.n6 0.0755
R691 VSS.n424 VSS.n6 0.0755
R692 VSS.n425 VSS.n424 0.0755
R693 VSS.n425 VSS.n2 0.0755
R694 VSS.n152 VSS.n97 0.0755
R695 VSS.n320 VSS.n269 0.0755
R696 VSS.n308 VSS.n307 0.0755
R697 VSS.n290 VSS.n289 0.0755
R698 VSS.n289 VSS.n285 0.0755
R699 VSS.n285 VSS.n0 0.0755
R700 VSS.n147 VSS.n100 0.0749375
R701 VSS.n146 VSS.n101 0.0749375
R702 VSS.n143 VSS.n142 0.0749375
R703 VSS.n139 VSS.n103 0.0749375
R704 VSS.n138 VSS.n105 0.0749375
R705 VSS.n235 VSS.n234 0.074
R706 VSS.n225 VSS.n60 0.0730625
R707 VSS.n167 VSS.n166 0.0695
R708 VSS.n140 VSS.n104 0.0695
R709 VSS.n179 VSS.n84 0.0695
R710 VSS.n177 VSS.n176 0.0695
R711 VSS.n173 VSS.n86 0.0695
R712 VSS.n172 VSS.n88 0.0695
R713 VSS.n169 VSS.n168 0.0695
R714 VSS.n164 VSS.n90 0.0695
R715 VSS.n163 VSS.n92 0.0695
R716 VSS.n160 VSS.n159 0.0695
R717 VSS.n156 VSS.n94 0.0695
R718 VSS.n155 VSS.n96 0.0695
R719 VSS.n153 VSS.n152 0.0695
R720 VSS.n307 VSS.n306 0.065
R721 VSS.n304 VSS.n276 0.065
R722 VSS.n303 VSS.n278 0.065
R723 VSS.n300 VSS.n299 0.065
R724 VSS.n296 VSS.n281 0.065
R725 VSS.n295 VSS.n283 0.065
R726 VSS.n292 VSS.n291 0.065
R727 VSS.n270 VSS.n267 0.0614375
R728 VSS.n215 VSS.n64 0.0573125
R729 VSS.n183 VSS.n82 0.056
R730 VSS.n184 VSS.n81 0.056
R731 VSS.n188 VSS.n187 0.056
R732 VSS.n191 VSS.n79 0.056
R733 VSS.n192 VSS.n77 0.056
R734 VSS.n196 VSS.n195 0.056
R735 VSS.n199 VSS.n75 0.056
R736 VSS.n200 VSS.n73 0.056
R737 VSS.n204 VSS.n203 0.056
R738 VSS.n207 VSS.n71 0.056
R739 VSS.n208 VSS.n69 0.056
R740 VSS.n212 VSS.n211 0.056
R741 VSS.n218 VSS.n67 0.056
R742 VSS.n219 VSS.n65 0.056
R743 VSS.n223 VSS.n222 0.056
R744 VSS.n227 VSS.n63 0.056
R745 VSS.n228 VSS.n61 0.056
R746 VSS.n232 VSS.n231 0.056
R747 VSS.n236 VSS.n59 0.056
R748 VSS.n237 VSS.n57 0.056
R749 VSS.n241 VSS.n240 0.056
R750 VSS.n244 VSS.n55 0.056
R751 VSS.n245 VSS.n53 0.056
R752 VSS.n249 VSS.n248 0.056
R753 VSS.n252 VSS.n51 0.056
R754 VSS.n254 VSS.n253 0.056
R755 VSS.n348 VSS.n48 0.056
R756 VSS.n347 VSS.n49 0.056
R757 VSS.n344 VSS.n343 0.056
R758 VSS.n340 VSS.n258 0.056
R759 VSS.n339 VSS.n260 0.056
R760 VSS.n336 VSS.n335 0.056
R761 VSS.n332 VSS.n262 0.056
R762 VSS.n331 VSS.n264 0.056
R763 VSS.n328 VSS.n327 0.056
R764 VSS.n324 VSS.n266 0.056
R765 VSS.n323 VSS.n268 0.056
R766 VSS.n321 VSS.n320 0.056
R767 VSS.n350 VSS.n349 0.055625
R768 VSS.n361 VSS.n360 0.055625
R769 VSS VSS.n0 0.054875
R770 VSS.n217 VSS.n214 0.0516875
R771 VSS.n286 VSS.n1 0.0498125
R772 VSS.n131 VSS.n106 0.04925
R773 VSS.n130 VSS.n109 0.04925
R774 VSS.n127 VSS.n126 0.04925
R775 VSS.n123 VSS.n111 0.04925
R776 VSS.n122 VSS.n113 0.04925
R777 VSS.n119 VSS.n118 0.04925
R778 VSS.n116 VSS.n115 0.04925
R779 VSS.n362 VSS.n37 0.04925
R780 VSS.n363 VSS.n35 0.04925
R781 VSS.n367 VSS.n366 0.04925
R782 VSS.n370 VSS.n33 0.04925
R783 VSS.n371 VSS.n31 0.04925
R784 VSS.n375 VSS.n374 0.04925
R785 VSS.n378 VSS.n29 0.04925
R786 VSS.n379 VSS.n27 0.04925
R787 VSS.n383 VSS.n382 0.04925
R788 VSS.n386 VSS.n25 0.04925
R789 VSS.n387 VSS.n23 0.04925
R790 VSS.n391 VSS.n390 0.04925
R791 VSS.n394 VSS.n21 0.04925
R792 VSS.n395 VSS.n19 0.04925
R793 VSS.n399 VSS.n398 0.04925
R794 VSS.n402 VSS.n17 0.04925
R795 VSS.n403 VSS.n15 0.04925
R796 VSS.n407 VSS.n406 0.04925
R797 VSS.n410 VSS.n13 0.04925
R798 VSS.n411 VSS.n11 0.04925
R799 VSS.n415 VSS.n414 0.04925
R800 VSS.n418 VSS.n9 0.04925
R801 VSS.n419 VSS.n7 0.04925
R802 VSS.n423 VSS.n422 0.04925
R803 VSS.n426 VSS.n5 0.04925
R804 VSS.n427 VSS.n3 0.04925
R805 VSS.n316 VSS.n272 0.0485
R806 VSS.n315 VSS.n273 0.0485
R807 VSS.n312 VSS.n311 0.0485
R808 VSS.n308 VSS.n274 0.0485
R809 VSS.n136 VSS.n135 0.0455
R810 VSS.n150 VSS.n149 0.044
R811 VSS.n351 VSS.n350 0.042949
R812 VSS.n360 VSS.n359 0.042949
R813 VSS.n216 VSS.n215 0.0393125
R814 VSS.n217 VSS.n216 0.0366875
R815 VSS.n151 VSS.n150 0.032
R816 VSS.n135 VSS.n134 0.0299375
R817 VSS.n272 VSS.n269 0.0275
R818 VSS.n316 VSS.n315 0.0275
R819 VSS.n312 VSS.n273 0.0275
R820 VSS.n311 VSS.n274 0.0275
R821 VSS.n134 VSS.n106 0.02675
R822 VSS.n131 VSS.n130 0.02675
R823 VSS.n127 VSS.n109 0.02675
R824 VSS.n126 VSS.n111 0.02675
R825 VSS.n123 VSS.n122 0.02675
R826 VSS.n119 VSS.n113 0.02675
R827 VSS.n118 VSS.n116 0.02675
R828 VSS.n115 VSS.n37 0.02675
R829 VSS.n363 VSS.n362 0.02675
R830 VSS.n366 VSS.n35 0.02675
R831 VSS.n367 VSS.n33 0.02675
R832 VSS.n371 VSS.n370 0.02675
R833 VSS.n374 VSS.n31 0.02675
R834 VSS.n375 VSS.n29 0.02675
R835 VSS.n379 VSS.n378 0.02675
R836 VSS.n382 VSS.n27 0.02675
R837 VSS.n383 VSS.n25 0.02675
R838 VSS.n387 VSS.n386 0.02675
R839 VSS.n390 VSS.n23 0.02675
R840 VSS.n391 VSS.n21 0.02675
R841 VSS.n395 VSS.n394 0.02675
R842 VSS.n398 VSS.n19 0.02675
R843 VSS.n399 VSS.n17 0.02675
R844 VSS.n403 VSS.n402 0.02675
R845 VSS.n406 VSS.n15 0.02675
R846 VSS.n407 VSS.n13 0.02675
R847 VSS.n411 VSS.n410 0.02675
R848 VSS.n414 VSS.n11 0.02675
R849 VSS.n415 VSS.n9 0.02675
R850 VSS.n419 VSS.n418 0.02675
R851 VSS.n422 VSS.n7 0.02675
R852 VSS.n423 VSS.n5 0.02675
R853 VSS.n427 VSS.n426 0.02675
R854 VSS.n429 VSS.n3 0.02675
R855 VSS.n214 VSS.n213 0.0243125
R856 VSS.n350 VSS.n46 0.020375
R857 VSS.n360 VSS.n38 0.020375
R858 VSS.n184 VSS.n183 0.02
R859 VSS.n187 VSS.n81 0.02
R860 VSS.n188 VSS.n79 0.02
R861 VSS.n192 VSS.n191 0.02
R862 VSS.n195 VSS.n77 0.02
R863 VSS.n196 VSS.n75 0.02
R864 VSS.n200 VSS.n199 0.02
R865 VSS.n203 VSS.n73 0.02
R866 VSS.n204 VSS.n71 0.02
R867 VSS.n208 VSS.n207 0.02
R868 VSS.n211 VSS.n69 0.02
R869 VSS.n212 VSS.n67 0.02
R870 VSS.n219 VSS.n218 0.02
R871 VSS.n222 VSS.n65 0.02
R872 VSS.n223 VSS.n63 0.02
R873 VSS.n228 VSS.n227 0.02
R874 VSS.n231 VSS.n61 0.02
R875 VSS.n232 VSS.n59 0.02
R876 VSS.n237 VSS.n236 0.02
R877 VSS.n240 VSS.n57 0.02
R878 VSS.n241 VSS.n55 0.02
R879 VSS.n245 VSS.n244 0.02
R880 VSS.n248 VSS.n53 0.02
R881 VSS.n249 VSS.n51 0.02
R882 VSS.n254 VSS.n252 0.02
R883 VSS.n253 VSS.n48 0.02
R884 VSS.n348 VSS.n347 0.02
R885 VSS.n344 VSS.n49 0.02
R886 VSS.n343 VSS.n258 0.02
R887 VSS.n340 VSS.n339 0.02
R888 VSS.n336 VSS.n260 0.02
R889 VSS.n335 VSS.n262 0.02
R890 VSS.n332 VSS.n331 0.02
R891 VSS.n328 VSS.n264 0.02
R892 VSS.n327 VSS.n266 0.02
R893 VSS.n324 VSS.n323 0.02
R894 VSS.n321 VSS.n268 0.02
R895 VSS.n224 VSS.n64 0.0186875
R896 VSS VSS.n431 0.017375
R897 VSS.n319 VSS.n270 0.0145625
R898 VSS.n306 VSS.n276 0.011
R899 VSS.n304 VSS.n303 0.011
R900 VSS.n300 VSS.n278 0.011
R901 VSS.n299 VSS.n281 0.011
R902 VSS.n296 VSS.n295 0.011
R903 VSS.n292 VSS.n283 0.011
R904 VSS.n291 VSS.n290 0.011
R905 VSS.n166 VSS.n165 0.0065
R906 VSS.n107 VSS.n104 0.0065
R907 VSS.n177 VSS.n84 0.0065
R908 VSS.n176 VSS.n86 0.0065
R909 VSS.n173 VSS.n172 0.0065
R910 VSS.n169 VSS.n88 0.0065
R911 VSS.n168 VSS.n90 0.0065
R912 VSS.n164 VSS.n163 0.0065
R913 VSS.n160 VSS.n92 0.0065
R914 VSS.n159 VSS.n94 0.0065
R915 VSS.n156 VSS.n155 0.0065
R916 VSS.n153 VSS.n96 0.0065
R917 VSS.n226 VSS.n225 0.0029375
R918 VSS.n234 VSS.n56 0.002
R919 VSS.n100 VSS.n97 0.0010625
R920 VSS.n147 VSS.n146 0.0010625
R921 VSS.n143 VSS.n101 0.0010625
R922 VSS.n142 VSS.n103 0.0010625
R923 VSS.n139 VSS.n138 0.0010625
R924 VSS.n136 VSS.n105 0.0010625
C0 vbt ca 0.02106f
C1 cb cq 0
C2 gcp ln 2.31943f
C3 VDD co 0.40417f
C4 enb cb 0.00427f
C5 nb gln 0.08015f
C6 ct gcn 1.15064f
C7 vgr mRpCa 0.15627f
C8 ct ca 0.37966f
C9 VDD cx 0.26162f
C10 nb glp 0.10638f
C11 cb ln 0.24663f
C12 gln glp 0.84179f
C13 ca gcn 3.24009f
C14 VDD vb 5.17787f
C15 enb lp 0.05f
C16 gln mRpLa 0.1297f
C17 vgr lp 0.18006f
C18 vbt vb 0.93601f
C19 tL inn 0.77998f
C20 q cq 1.46447f
C21 co gcn 0.00689f
C22 VDD gcp 1.67315f
C23 ln lp 0.86658f
C24 mRpLb vb 0.70349f
C25 mRpLa glp 2.67965f
C26 q vgr 0.1075f
C27 co ca 0.34422f
C28 vbt gcp 0.00317f
C29 inp lp 0.15192f
C30 cx gcn 0.01262f
C31 VDD cb 1.08813f
C32 nb enb 0.34739f
C33 cx ca 0.19535f
C34 gcn vb 2.48838f
C35 VDD mRpCa 0.22931f
C36 enb gln 0.01156f
C37 nb vgr 0.09488f
C38 cb vbt 0.00161f
C39 mRpCb vgr 0.0027f
C40 vgr gln 2.33978f
C41 ct gcp 1.49061f
C42 nb ln 0.22789f
C43 enb glp 0.00176f
C44 gcp gcn 1.5058f
C45 co cx 0.30108f
C46 gln ln 0.9762f
C47 vgr glp 1.30234f
C48 VDD lp 1.64949f
C49 inp nb 1.6067f
C50 gcp ca 1.65407f
C51 ct cb 0.22508f
C52 vgr mRpLa 0.17634f
C53 inp gln 0.30002f
C54 ln glp 2.65861f
C55 vbt lp 0.14942f
C56 cb gcn 2.07261f
C57 VDD q 1.28185f
C58 mRpLa ln 0.05539f
C59 mRpCa gcn 0.42828f
C60 inp glp 2.08264f
C61 cb ca 1.75008f
C62 ct lp 0.00147f
C63 VDD nb 0.15154f
C64 cx gcp 0
C65 VDD mRpCb 0.28387f
C66 co cb 0
C67 VDD gln 1.67491f
C68 lp gcn 0.00441f
C69 nb vbt 0.13617f
C70 gcp vb 0.79633f
C71 ca lp 0.94964f
C72 tL lp 0.40982f
C73 vbt gln 0.36652f
C74 VDD glp 1.0466f
C75 inn lp 0.18871f
C76 q gcn 0.0493f
C77 enb ln 0.10666f
C78 cx cb 0.17701f
C79 gln mRpLb 0.55439f
C80 vgr ln 2.78384f
C81 VDD mRpLa 0.23785f
C82 vbt glp 0.86401f
C83 q ca 0.0045f
C84 inp enb 0.07276f
C85 ct nb 1.42544f
C86 inp vgr 0.27163f
C87 mRpLb glp 0.09894f
C88 mRpCa vb 2.65704f
C89 vbt mRpLa 0.06822f
C90 nb gcn 0.25069f
C91 mRpCb gcn 1.63858f
C92 gln gcn 0
C93 co q 0.02598f
C94 mRpLb mRpLa 0.08501f
C95 cb gcp 0.40538f
C96 inp ln 0.46647f
C97 nb ca 0.51718f
C98 tL nb 0.96547f
C99 gcp mRpCa 0.49639f
C100 nb inn 0.24618f
C101 tL gln 0.69379f
C102 lp vb 0.23357f
C103 gln inn 2.16324f
C104 VDD cq 0.3678f
C105 cx q 0.00495f
C106 VDD enb 0.1277f
C107 tL glp 0.67186f
C108 VDD vgr 2.06068f
C109 inn glp 0.15026f
C110 q vb 0.81306f
C111 gcp lp 2.05057f
C112 enb vbt 0.99337f
C113 vgr vbt 0.84123f
C114 VDD ln 1.61359f
C115 q gcp 0.05927f
C116 vgr mRpLb 1.38046f
C117 vbt ln 0.8843f
C118 inp VDD 0.53555f
C119 cb lp 0.8057f
C120 mRpCb vb 0.45824f
C121 ct enb 0.06023f
C122 gln vb 2.67169f
C123 cq gcn 0
C124 inp vbt 0.42431f
C125 enb gcn 0.00683f
C126 q cb 0
C127 nb gcp 0.47167f
C128 ca cq 0
C129 vgr gcn 1.26016f
C130 mRpCb gcp 0.65172f
C131 glp vb 3.11f
C132 q mRpCa 0.062f
C133 gln gcp 0
C134 enb ca 0.01232f
C135 ct ln 0.12331f
C136 ln gcn 4.21825f
C137 mRpLa vb 0.99437f
C138 vgr inn 0.03485f
C139 co cq 1.38136f
C140 gcp glp 0
C141 nb cb 0.10584f
C142 ca ln 0.33477f
C143 tL ln 0.51679f
C144 inn ln 0.93344f
C145 VDD vbt 0.67795f
C146 mRpCb mRpCa 0.1012f
C147 inp tL 0.00244f
C148 cx cq 0
C149 VDD mRpLb 0.03325f
C150 inp inn 0.31251f
C151 nb lp 0.05286f
C152 gln lp 4.14396f
C153 vgr vb 9.84229f
C154 VDD gcn 1.88779f
C155 enb gcp 0.00724f
C156 lp glp 0.74193f
C157 ln vb 0.22435f
C158 VDD ca 0.90655f
C159 VDD tL 0.1532f
C160 vbt gcn 0
C161 vgr gcp 1.70144f
C162 VDD inn 0.7383f
C163 nb VSS 8.87348f
C164 q VSS 2.10315f
C165 enb VSS 1.09775f
C166 inp VSS 18.4062f
C167 inn VSS 19.7686f
C168 VDD VSS 74.9038f
C169 ct VSS 0.76041f
C170 tL VSS 0.74497f
C171 co VSS 0.93287f
C172 cx VSS 1.22685f
C173 ca VSS 2.16345f
C174 cb VSS 1.4863f
C175 cq VSS 0.85781f
C176 mRpCb VSS 1.49266f
C177 mRpCa VSS 0.90894f
C178 mRpLb VSS 1.62302f
C179 mRpLa VSS 0.73025f
C180 vgr VSS 7.37228f
C181 vbt VSS 1.06713f
C182 ln VSS 26.4717f
C183 lp VSS 23.7751f
C184 gcn VSS 4.96001f
C185 gcp VSS 6.66569f
C186 gln VSS 4.42568f
C187 glp VSS 3.93448f
C188 vb VSS 64.419f
C189 VDD.t0 VSS 0.0401163f
C190 VDD.t3 VSS 0.0310662f
C191 VDD.n0 VSS 0.160895f
C192 VDD.n1 VSS -0.552601f
C193 VDD.n2 VSS 0.103347f
C194 VDD.n3 VSS 0.0516736f
C195 VDD.n4 VSS 0.265754f
C196 VDD.n5 VSS 0.0516736f
C197 VDD.n6 VSS 0.103347f
C198 VDD.n7 VSS 0.00363753f
C199 VDD.n8 VSS 0.103347f
C200 VDD.n9 VSS 0.103379f
C201 VDD.n10 VSS 0.103347f
C202 VDD.t19 VSS 0.0319497f
C203 VDD.n11 VSS 0.103347f
C204 VDD.n12 VSS 0.0516736f
C205 VDD.n13 VSS 0.103347f
C206 VDD.n14 VSS 0.0516736f
C207 VDD.n15 VSS 0.103347f
C208 VDD.n16 VSS 0.0516736f
C209 VDD.n17 VSS 0.103347f
C210 VDD.n18 VSS 0.0516736f
C211 VDD.n19 VSS 0.103347f
C212 VDD.n20 VSS 0.0516736f
C213 VDD.n21 VSS 0.103347f
C214 VDD.n22 VSS 0.0516736f
C215 VDD.n23 VSS 0.103347f
C216 VDD.n24 VSS 0.0516736f
C217 VDD.n25 VSS 0.103347f
C218 VDD.n26 VSS 0.0516736f
C219 VDD.n27 VSS 0.103347f
C220 VDD.n28 VSS 0.0516736f
C221 VDD.n29 VSS 0.103347f
C222 VDD.n30 VSS 0.0516736f
C223 VDD.n31 VSS 0.0913361f
C224 VDD.n32 VSS 0.0516736f
C225 VDD.n33 VSS 0.194882f
C226 VDD.n34 VSS 0.0516736f
C227 VDD.t15 VSS 0.0451547f
C228 VDD.n35 VSS 0.135002f
C229 VDD.n36 VSS 0.0424166f
C230 VDD.t9 VSS 0.0451547f
C231 VDD.t17 VSS 0.0319497f
C232 VDD.t13 VSS 0.0514746f
C233 VDD.n37 VSS 0.131588f
C234 VDD.n38 VSS 0.0516736f
C235 VDD.n39 VSS 0.103347f
C236 VDD.n40 VSS 0.0516736f
C237 VDD.t7 VSS 0.0514746f
C238 VDD.t11 VSS 0.0355873f
C239 VDD.n41 VSS 0.1402f
C240 VDD.n42 VSS 0.0516736f
C241 VDD.t2 VSS 0.0944403f
C242 VDD.n43 VSS 0.0601983f
C243 VDD.n44 VSS 1.08247f
C244 VDD.n45 VSS 1.02442f
C245 VDD.n46 VSS 0.200788f
C246 VDD.n47 VSS 0.0516736f
C247 VDD.n48 VSS 0.0516736f
C248 VDD.n49 VSS 0.0658814f
C249 VDD.n50 VSS 0.131588f
C250 VDD.n51 VSS 0.053353f
C251 VDD.n52 VSS 0.0642019f
C252 VDD.n53 VSS 0.0516736f
C253 VDD.n54 VSS 0.0516736f
C254 VDD.n55 VSS 0.177172f
C255 VDD.n56 VSS 0.0553668f
C256 VDD.n57 VSS 0.0764756f
C257 VDD.n58 VSS 0.0710551f
C258 VDD.n59 VSS 0.141426f
C259 VDD.n60 VSS 0.0658814f
C260 VDD.n61 VSS 0.135002f
C261 VDD.n62 VSS 0.0658814f
C262 VDD.n63 VSS 0.0226927f
C263 VDD.n64 VSS 0.0562503f
C264 VDD.n65 VSS 0.0516736f
C265 VDD.n66 VSS 0.0538704f
C266 VDD.t5 VSS 0.0319497f
C267 VDD.n67 VSS 0.141426f
C268 VDD.n68 VSS 0.0636846f
C269 VDD.n69 VSS 0.0516736f
C270 VDD.n70 VSS 0.0516736f
C271 VDD.n71 VSS 0.103347f
C272 VDD.n72 VSS 0.103347f
C273 VDD.n73 VSS 0.0516736f
C274 VDD.n74 VSS 0.0516736f
C275 VDD.n75 VSS 0.103347f
C276 VDD.n76 VSS 0.103347f
C277 VDD.n77 VSS 0.0516736f
C278 VDD.n78 VSS 0.0516736f
C279 VDD.n79 VSS 0.103347f
C280 VDD.n80 VSS 0.103347f
C281 VDD.n81 VSS 0.0516736f
C282 VDD.n82 VSS 0.0516736f
C283 VDD.n83 VSS 0.065364f
C284 VDD.t1 VSS 0.173582f
C285 VDD.t10 VSS 0.827525f
C286 VDD.t6 VSS 0.865691f
C287 VDD.t12 VSS 0.919474f
C288 VDD.t16 VSS 0.919474f
C289 VDD.t8 VSS 0.88477f
C290 VDD.t14 VSS 0.88477f
C291 VDD.t4 VSS 1.02892f
C292 VDD.t18 VSS 0.447551f
C293 VDD.n84 VSS 0.0062801f
C294 VDD.n85 VSS -0.41935f
C295 VDD.n86 VSS 0.0896566f
C296 VDD.n87 VSS 0.0516736f
C297 VDD.n88 VSS 0.0516736f
C298 VDD.n89 VSS 0.103347f
C299 VDD.n90 VSS 0.103347f
C300 VDD.n91 VSS 0.0516736f
C301 VDD.n92 VSS 0.0516736f
C302 VDD.n93 VSS 0.103347f
C303 VDD.n94 VSS 0.103347f
C304 VDD.n95 VSS 0.0516736f
C305 VDD.n96 VSS 0.0516736f
C306 VDD.n97 VSS 0.103347f
C307 VDD.n98 VSS 0.103347f
C308 VDD.n99 VSS 0.0516736f
C309 VDD.n100 VSS 0.0516736f
C310 VDD.n101 VSS 0.103347f
C311 VDD.n102 VSS 0.103347f
C312 VDD.n103 VSS 0.0516736f
C313 VDD.n104 VSS 0.0516736f
C314 VDD.n105 VSS 0.103347f
C315 VDD.n106 VSS 0.103347f
C316 VDD.n107 VSS 0.0516736f
C317 VDD.n108 VSS 0.0516736f
C318 VDD.n109 VSS 0.103347f
C319 VDD.n110 VSS 0.103347f
C320 VDD.n111 VSS 0.0516736f
C321 VDD.n112 VSS 0.0516736f
C322 VDD.n113 VSS 0.177172f
C323 VDD.n114 VSS 0.0553668f
C324 VDD.n115 VSS 0.0547778f
C325 VDD.n116 VSS 0.103347f
C326 VDD.n117 VSS 0.0556772f
C327 VDD.n118 VSS 0.141426f
C328 VDD.n119 VSS 0.0993434f
C329 VDD.n120 VSS 0.136857f
C330 VDD.n121 VSS 0.208517f
C331 VDD.n122 VSS 0.173407f
C332 VDD.n123 VSS 0.0645681f
C333 VDD.n124 VSS 0.103347f
C334 VDD.n125 VSS 0.103347f
C335 VDD.n126 VSS 0.103347f
C336 VDD.n127 VSS 0.103347f
C337 VDD.n128 VSS 0.0950771f
C338 VDD.n129 VSS 0.0597923f
C339 VDD.n130 VSS 0.0516736f
C340 VDD.n131 VSS 0.103347f
C341 VDD.n132 VSS 0.103347f
C342 VDD.n133 VSS 0.103347f
C343 VDD.n134 VSS 0.0516736f
C344 VDD.n135 VSS 0.0516736f
C345 VDD.n136 VSS 0.177172f
C346 VDD.n137 VSS 0.0553668f
C347 VDD.n138 VSS 0.0599436f
C348 VDD.n139 VSS 0.0776377f
C349 VDD.n140 VSS 0.381701f
C350 VDD.n141 VSS -0.705696f
C351 inn.t1 VSS 0.680136f
C352 inn.t0 VSS 2.55568f
C353 inn.n0 VSS 1.11747f
C354 inn.n1 VSS 0.0790905f
C355 inp.t1 VSS 0.743672f
C356 inp.t0 VSS 2.77502f
C357 inp.n0 VSS 1.21982f
C358 inp.n1 VSS 0.0827073f
C359 enb.t0 VSS 0.058038f
C360 q.t0 VSS 0.307771f
C361 q.t1 VSS 0.080495f
C362 q.n0 VSS 0.582563f
C363 nb.t1 VSS 2.80106f
C364 nb.t0 VSS 0.074824f
C365 nb.n0 VSS 0.521706f
C366 nb.t2 VSS 0.110617f
C367 nb.n1 VSS 0.603215f
.ends
