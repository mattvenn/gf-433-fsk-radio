* rx_lim: magic R+C extraction of layout/rx_lim.gds (layout/gen/pex.sh)
* rcfix.py: split-net C to VSS scaled by (S - K) / S on 6 nets (coupling double count removed)
* extracted 2026-11-15T23:47:50+01:00 with magic 8.3.642, mode rc, from rx_lim.gds
.subckt rx_lim VDD VSS inp inn q nb enb
X0 mRpLa mRpLa vb vb pfet_03v3 ad=0.42p pd=2.84u as=0.42p ps=2.84u w=0.42u l=1u
X1 cb cb VDD.t19 VDD.t18 pfet_03v3 ad=1p pd=4u as=0.45p ps=2.9u w=1u l=0.5u
X2 cx cb VDD.t17 VDD.t16 pfet_03v3 ad=2p pd=6u as=0.9p ps=4.9u w=2u l=0.5u
X3 q.t0 cq VDD.t3 VDD.t2 pfet_03v3 ad=5p pd=12u as=2.25p ps=10.9u w=5u l=0.28u
X4 cb ca VDD.t13 VDD.t12 pfet_03v3 ad=1.7p pd=5.4u as=0.765p ps=4.3u w=1.7u l=0.5u
X5 ct gcn cb VSS.t2 nfet_03v3 ad=1p pd=3u as=1p ps=3u w=2u l=0.5u
X6 vb vbt VSS.t9 ppolyf_u_1k r_width=1u r_length=0.15m
X7 tL gln lp VSS.t8 nfet_03v3 ad=2p pd=5u as=2p ps=5u w=4u l=0.5u
X8 VSS.t16 vb VSS.t16 VSS.t15 nfet_03v3 ad=3.4398p pd=12.845u as=0 ps=0 w=12.285u l=10u
X9 lp gcp lp lp pfet_03v3 ad=12.285p pd=26.57u as=24.57p ps=53.14u w=12.285u l=10u
X10 ct gcp ca VSS.t29 nfet_03v3 ad=1p pd=3u as=2p ps=6u w=2u l=0.5u
X11 VDD.t0 ln VSS.t0 ppolyf_u r_width=1u r_length=28.56u
X12 q.t1 cq VSS.t12 VSS.t11 nfet_03v3 ad=2p pd=6u as=0.9p ps=4.9u w=2u l=0.28u
X13 mRpCa mRpCa vb vb pfet_03v3 ad=0.42p pd=2.84u as=0.42p ps=2.84u w=0.42u l=1u
X14 cq co VDD.t7 VDD.t6 pfet_03v3 ad=1.25p pd=4.5u as=0.5625p ps=3.4u w=1.25u l=0.28u
X15 ct nb.t0 VSS.t28 VSS.t27 nfet_03v3 ad=2p pd=6u as=0.9p ps=4.9u w=2u l=0.5u
X16 mRpCa mRpCa gcp gcp pfet_03v3 ad=0.42p pd=2.84u as=0.42p ps=2.84u w=0.42u l=1u
X17 inn.t1 gln inn.t1 inn.t0 pfet_03v3 ad=12.285p pd=26.57u as=0 ps=0 w=12.285u l=10u
X18 co cx VSS.t22 VSS.t21 nfet_03v3 ad=1p pd=4u as=0.45p ps=2.9u w=1u l=0.5u
X19 mRpLb mRpLb vb vb pfet_03v3 ad=0.42p pd=2.84u as=0.42p ps=2.84u w=0.42u l=1u
X20 gcp vgr vb vb pfet_03v3 ad=0.42p pd=2.84u as=0.42p ps=2.84u w=0.42u l=12u
X21 ca gcp ct VSS.t30 nfet_03v3 ad=2p pd=6u as=1p ps=3u w=2u l=0.5u
X22 ln glp tL VSS.t4 nfet_03v3 ad=4p pd=10u as=2p ps=5u w=4u l=0.5u
X23 mRpCb mRpCb gcn gcn pfet_03v3 ad=0.42p pd=2.84u as=0.42p ps=2.84u w=0.42u l=1u
X24 VDD.t1 lp VSS.t10 ppolyf_u r_width=1u r_length=28.56u
X25 gln vgr vb vb pfet_03v3 ad=0.42p pd=2.84u as=0.42p ps=2.84u w=0.42u l=12u
X26 mRpLb mRpLb gln gln pfet_03v3 ad=0.42p pd=2.84u as=0.42p ps=2.84u w=0.42u l=1u
X27 glp vgr vb vb pfet_03v3 ad=0.42p pd=2.84u as=0.42p ps=2.84u w=0.42u l=12u
X28 mRpCb mRpCb vb vb pfet_03v3 ad=0.42p pd=2.84u as=0.42p ps=2.84u w=0.42u l=1u
X29 vbt enb.t0 VDD.t5 VDD.t4 pfet_03v3 ad=1p pd=4u as=0.45p ps=2.9u w=1u l=0.28u
X30 cx cx VSS.t20 VSS.t19 nfet_03v3 ad=1p pd=4u as=0.45p ps=2.9u w=1u l=0.5u
X31 cq co VSS.t18 VSS.t17 nfet_03v3 ad=0.5p pd=3u as=0.225p ps=1.9u w=0.5u l=0.28u
X32 vgr nb.t2 VSS.t24 VSS.t23 nfet_03v3 ad=0.42p pd=2.84u as=0.42p ps=2.84u w=0.42u l=50u
X33 ca cb VDD.t15 VDD.t14 pfet_03v3 ad=1.7p pd=5.4u as=0.765p ps=4.3u w=1.7u l=0.5u
X34 tL glp ln VSS.t3 nfet_03v3 ad=2p pd=5u as=4p ps=10u w=4u l=0.5u
X35 VSS.t6 vb VSS.t5 ppolyf_u_1k r_width=1u r_length=0.10002m
X36 vgr vgr vb vb pfet_03v3 ad=4p pd=10u as=4p ps=10u w=4u l=1u
X37 mRpLa mRpLa glp glp pfet_03v3 ad=0.42p pd=2.84u as=0.42p ps=2.84u w=0.42u l=1u
X38 ca ca VDD.t11 VDD.t10 pfet_03v3 ad=1p pd=4u as=0.45p ps=2.9u w=1u l=0.5u
X39 co ca VDD.t9 VDD.t8 pfet_03v3 ad=2p pd=6u as=0.9p ps=4.9u w=2u l=0.5u
X40 tL nb.t1 VSS.t26 VSS.t25 nfet_03v3 ad=2p pd=6u as=0.9p ps=4.9u w=2u l=0.5u
X41 VSS.t14 vb VSS.t14 VSS.t13 nfet_03v3 ad=5.52825p pd=25.47u as=0 ps=0 w=12.285u l=10u
X42 cb gcn ct VSS.t1 nfet_03v3 ad=1p pd=3u as=1p ps=3u w=2u l=0.5u
X43 gcn vgr vb vb pfet_03v3 ad=0.42p pd=2.84u as=0.42p ps=2.84u w=0.42u l=12u
X44 inp.t1 glp inp.t1 inp.t0 pfet_03v3 ad=12.285p pd=26.57u as=0 ps=0 w=12.285u l=10u
X45 ln gcn ln ln pfet_03v3 ad=12.285p pd=26.57u as=24.57p ps=53.14u w=12.285u l=10u
X46 lp gln tL VSS.t7 nfet_03v3 ad=2p pd=5u as=2p ps=5u w=4u l=0.5u
R0 q q.n0 21.0037
R1 q.n0 q.t1 3.71774
R2 q.n0 q.t0 3.20879
R3 enb enb.t0 37.3349
R4 nb nb.t1 39.6725
R5 nb.n0 nb.t0 33.8225
R6 nb nb.t2 19.7819
R7 nb.n1 nb 17.3966
R8 nb.n1 nb.n0 8.22129
R9 nb nb.n1 3.9155
R10 nb.n0 nb 2.12971
R11 inp.n0 inp.t0 519.854
R12 inp.n1 inp.t1 9.0579
R13 inp inp.n1 8.57655
R14 inp.n0 inp.t1 7.67474
R15 inp inp.n0 1.15037
R16 inp.n1 inp 0.0727368
R17 inn.n0 inn.t0 519.692
R18 inn.n1 inn.t1 8.91106
R19 inn inn.n1 8.73761
R20 inn.n0 inn.t1 7.51369
R21 inn inn.n0 1.15037
R22 inn.n1 inn 0.0585263
R23 VDD.n72 VDD.t4 25973.8
R24 VDD.n72 VDD.t10 2416.38
R25 VDD.t18 VDD.t16 170.649
R26 VDD.t16 VDD.t8 158.238
R27 VDD.t12 VDD.t18 158.238
R28 VDD.t14 VDD.t12 158.238
R29 VDD.t10 VDD.t14 158.238
R30 VDD.t8 VDD.t6 151.412
R31 VDD.t6 VDD.t2 144.587
R32 VDD.n137 VDD.t1 13.9154
R33 VDD.n137 VDD.t0 11.9496
R34 VDD.n138 VDD.n137 11.4885
R35 VDD.n113 VDD.t5 7.57826
R36 VDD.n63 VDD.t11 7.57826
R37 VDD.n56 VDD.t19 7.57826
R38 VDD.n38 VDD.t7 7.17766
R39 VDD.n32 VDD.t15 5.86488
R40 VDD.n58 VDD.t13 5.86488
R41 VDD.n34 VDD.t17 5.23234
R42 VDD.n47 VDD.t9 5.23234
R43 VDD.n41 VDD.t3 3.54058
R44 VDD.n123 VDD.n4 1.5755
R45 VDD.n130 VDD.n1 1.5755
R46 VDD.n93 VDD.n92 1.5755
R47 VDD.n109 VDD.n108 1.5755
R48 VDD.n67 VDD.n31 1.5755
R49 VDD.n86 VDD.n20 1.5755
R50 VDD.n43 VDD.n42 1.5755
R51 VDD.n53 VDD.n52 1.5755
R52 VDD.n116 VDD.n8 1.50139
R53 VDD.n136 VDD.n0 1.5005
R54 VDD.n135 VDD.n134 1.5005
R55 VDD.n133 VDD.n132 1.5005
R56 VDD.n3 VDD.n2 1.5005
R57 VDD.n127 VDD.n126 1.5005
R58 VDD.n125 VDD.n124 1.5005
R59 VDD.n122 VDD.n6 1.5005
R60 VDD.n121 VDD.n120 1.5005
R61 VDD.n119 VDD.n7 1.5005
R62 VDD.n118 VDD.n117 1.5005
R63 VDD.n115 VDD.n114 1.5005
R64 VDD.n112 VDD.n9 1.5005
R65 VDD.n111 VDD.n110 1.5005
R66 VDD.n11 VDD.n10 1.5005
R67 VDD.n106 VDD.n105 1.5005
R68 VDD.n104 VDD.n103 1.5005
R69 VDD.n15 VDD.n14 1.5005
R70 VDD.n98 VDD.n97 1.5005
R71 VDD.n96 VDD.n95 1.5005
R72 VDD.n19 VDD.n18 1.5005
R73 VDD.n91 VDD.n90 1.5005
R74 VDD.n89 VDD.n88 1.5005
R75 VDD.n22 VDD.n21 1.5005
R76 VDD.n83 VDD.n82 1.5005
R77 VDD.n81 VDD.n80 1.5005
R78 VDD.n26 VDD.n25 1.5005
R79 VDD.n75 VDD.n74 1.5005
R80 VDD.n71 VDD.n70 1.5005
R81 VDD.n30 VDD.n29 1.5005
R82 VDD.n65 VDD.n64 1.5005
R83 VDD.n62 VDD.n61 1.5005
R84 VDD.n60 VDD.n59 1.5005
R85 VDD.n57 VDD.n33 1.5005
R86 VDD.n55 VDD.n54 1.5005
R87 VDD.n48 VDD.n35 1.5005
R88 VDD.n50 VDD.n49 1.5005
R89 VDD.n46 VDD.n45 1.5005
R90 VDD.n40 VDD.n39 1.5005
R91 VDD.n44 VDD.n43 1.5005
R92 VDD.n37 VDD.n36 1.5005
R93 VDD.n52 VDD.n51 1.5005
R94 VDD.n67 VDD.n66 1.5005
R95 VDD.n69 VDD.n68 1.5005
R96 VDD.n28 VDD.n27 1.5005
R97 VDD.n77 VDD.n76 1.5005
R98 VDD.n79 VDD.n78 1.5005
R99 VDD.n24 VDD.n23 1.5005
R100 VDD.n85 VDD.n84 1.5005
R101 VDD.n87 VDD.n86 1.5005
R102 VDD.n94 VDD.n93 1.5005
R103 VDD.n17 VDD.n16 1.5005
R104 VDD.n100 VDD.n99 1.5005
R105 VDD.n102 VDD.n101 1.5005
R106 VDD.n13 VDD.n12 1.5005
R107 VDD.n108 VDD.n107 1.5005
R108 VDD.n5 VDD.n4 1.5005
R109 VDD.n129 VDD.n128 1.5005
R110 VDD.n131 VDD.n130 1.5005
R111 VDD.n139 VDD.n0 0.473314
R112 VDD.n42 VDD.n41 0.468196
R113 VDD.n139 VDD.n138 0.13081
R114 VDD VDD.n139 0.100472
R115 VDD.n129 VDD.n4 0.0755
R116 VDD.n130 VDD.n129 0.0755
R117 VDD.n93 VDD.n16 0.0755
R118 VDD.n100 VDD.n16 0.0755
R119 VDD.n101 VDD.n100 0.0755
R120 VDD.n101 VDD.n12 0.0755
R121 VDD.n108 VDD.n12 0.0755
R122 VDD.n68 VDD.n67 0.0755
R123 VDD.n68 VDD.n27 0.0755
R124 VDD.n77 VDD.n27 0.0755
R125 VDD.n78 VDD.n77 0.0755
R126 VDD.n78 VDD.n23 0.0755
R127 VDD.n85 VDD.n23 0.0755
R128 VDD.n86 VDD.n85 0.0755
R129 VDD.n43 VDD.n36 0.0755
R130 VDD.n52 VDD.n36 0.0755
R131 VDD.n49 VDD.n48 0.0755
R132 VDD.n64 VDD.n62 0.0755
R133 VDD.n71 VDD.n29 0.0755
R134 VDD.n74 VDD.n25 0.0755
R135 VDD.n81 VDD.n25 0.0755
R136 VDD.n82 VDD.n81 0.0755
R137 VDD.n82 VDD.n21 0.0755
R138 VDD.n89 VDD.n21 0.0755
R139 VDD.n90 VDD.n89 0.0755
R140 VDD.n90 VDD.n18 0.0755
R141 VDD.n96 VDD.n18 0.0755
R142 VDD.n97 VDD.n96 0.0755
R143 VDD.n97 VDD.n14 0.0755
R144 VDD.n104 VDD.n14 0.0755
R145 VDD.n105 VDD.n104 0.0755
R146 VDD.n105 VDD.n10 0.0755
R147 VDD.n111 VDD.n10 0.0755
R148 VDD.n112 VDD.n111 0.0755
R149 VDD.n114 VDD.n8 0.0755
R150 VDD.n118 VDD.n8 0.0755
R151 VDD.n119 VDD.n118 0.0755
R152 VDD.n120 VDD.n119 0.0755
R153 VDD.n120 VDD.n6 0.0755
R154 VDD.n125 VDD.n6 0.0755
R155 VDD.n126 VDD.n125 0.0755
R156 VDD.n126 VDD.n2 0.0755
R157 VDD.n133 VDD.n2 0.0755
R158 VDD.n134 VDD.n133 0.0755
R159 VDD.n134 VDD.n0 0.0755
R160 VDD.n54 VDD.n33 0.0755
R161 VDD.n60 VDD.n33 0.0755
R162 VDD.n61 VDD.n60 0.0755
R163 VDD.n110 VDD.n9 0.0755
R164 VDD.n115 VDD.n9 0.0755
R165 VDD.n117 VDD.n7 0.0755
R166 VDD.n121 VDD.n7 0.0755
R167 VDD.n122 VDD.n121 0.0755
R168 VDD.n136 VDD.n135 0.0755
R169 VDD.n116 VDD.n115 0.0754286
R170 VDD.n117 VDD.n116 0.0747857
R171 VDD.n55 VDD.n34 0.0730625
R172 VDD.n59 VDD.n32 0.0723125
R173 VDD.n92 VDD.n91 0.071
R174 VDD.n94 VDD.n19 0.071
R175 VDD.n95 VDD.n17 0.071
R176 VDD.n99 VDD.n98 0.071
R177 VDD.n102 VDD.n15 0.071
R178 VDD.n103 VDD.n13 0.071
R179 VDD.n107 VDD.n106 0.071
R180 VDD.n109 VDD.n11 0.071
R181 VDD.n114 VDD.n113 0.0696875
R182 VDD.n65 VDD.n31 0.068
R183 VDD.n66 VDD.n30 0.068
R184 VDD.n70 VDD.n69 0.068
R185 VDD.n75 VDD.n28 0.068
R186 VDD.n76 VDD.n26 0.068
R187 VDD.n80 VDD.n79 0.068
R188 VDD.n83 VDD.n24 0.068
R189 VDD.n84 VDD.n22 0.068
R190 VDD.n88 VDD.n87 0.068
R191 VDD.n91 VDD.n20 0.068
R192 VDD.n123 VDD.n122 0.0635
R193 VDD.n124 VDD.n5 0.0635
R194 VDD.n128 VDD.n127 0.0635
R195 VDD.n131 VDD.n3 0.0635
R196 VDD.n132 VDD.n1 0.0635
R197 VDD.n63 VDD.n29 0.0580625
R198 VDD.n47 VDD.n46 0.0573125
R199 VDD.n74 VDD.n73 0.056
R200 VDD.n41 VDD.n40 0.0516875
R201 VDD.n58 VDD.n57 0.0516875
R202 VDD.n73 VDD.n72 0.0471667
R203 VDD.n57 VDD.n56 0.0449375
R204 VDD.n44 VDD.n39 0.0395
R205 VDD.n45 VDD.n37 0.0395
R206 VDD.n51 VDD.n50 0.0395
R207 VDD.n53 VDD.n35 0.0395
R208 VDD.n46 VDD.n38 0.0393125
R209 VDD.n138 VDD.n136 0.0381875
R210 VDD.n40 VDD.n38 0.0366875
R211 VDD.n42 VDD.n39 0.0365
R212 VDD.n45 VDD.n44 0.0365
R213 VDD.n50 VDD.n37 0.0365
R214 VDD.n51 VDD.n35 0.0365
R215 VDD.n54 VDD.n53 0.0365
R216 VDD.n56 VDD.n55 0.0310625
R217 VDD.n59 VDD.n58 0.0243125
R218 VDD.n73 VDD.n71 0.02
R219 VDD.n49 VDD.n47 0.0186875
R220 VDD.n64 VDD.n63 0.0179375
R221 VDD.n124 VDD.n123 0.0125
R222 VDD.n127 VDD.n5 0.0125
R223 VDD.n128 VDD.n3 0.0125
R224 VDD.n132 VDD.n131 0.0125
R225 VDD.n135 VDD.n1 0.0125
R226 VDD.n61 VDD.n31 0.008
R227 VDD.n66 VDD.n65 0.008
R228 VDD.n69 VDD.n30 0.008
R229 VDD.n70 VDD.n28 0.008
R230 VDD.n76 VDD.n75 0.008
R231 VDD.n79 VDD.n26 0.008
R232 VDD.n80 VDD.n24 0.008
R233 VDD.n84 VDD.n83 0.008
R234 VDD.n87 VDD.n22 0.008
R235 VDD.n88 VDD.n20 0.008
R236 VDD.n113 VDD.n112 0.0063125
R237 VDD.n92 VDD.n19 0.005
R238 VDD.n95 VDD.n94 0.005
R239 VDD.n98 VDD.n17 0.005
R240 VDD.n99 VDD.n15 0.005
R241 VDD.n103 VDD.n102 0.005
R242 VDD.n106 VDD.n13 0.005
R243 VDD.n107 VDD.n11 0.005
R244 VDD.n110 VDD.n109 0.005
R245 VDD.n62 VDD.n32 0.0036875
R246 VDD.n48 VDD.n34 0.0029375
R247 VSS.n389 VSS.n45 102435
R248 VSS.n388 VSS.t25 96005.5
R249 VSS.n47 VSS.n43 94523.5
R250 VSS.n48 VSS.n46 60444.2
R251 VSS.n386 VSS.n46 57091.8
R252 VSS.n388 VSS.n387 49682.3
R253 VSS.t15 VSS.n47 37593.9
R254 VSS.t0 VSS.n389 36134.2
R255 VSS.n389 VSS.n388 31005.7
R256 VSS.n385 VSS.n46 26745.6
R257 VSS.n44 VSS.n43 4878.65
R258 VSS.n45 VSS.n44 4805.62
R259 VSS.t5 VSS.t23 3964.46
R260 VSS.n391 VSS.n44 3785.29
R261 VSS.n390 VSS.n45 3785.29
R262 VSS.n392 VSS.n43 3386.84
R263 VSS.n387 VSS.n386 2219.38
R264 VSS.n385 VSS.n384 1918.01
R265 VSS.n48 VSS.t19 1839.14
R266 VSS.t4 VSS.n387 1446.94
R267 VSS.n390 VSS.t9 1397.54
R268 VSS.t30 VSS.n385 1058.52
R269 VSS.n392 VSS.n391 952.611
R270 VSS.n391 VSS.n390 938.351
R271 VSS.t13 VSS.t15 933.624
R272 VSS.n47 VSS.t23 750.99
R273 VSS.t11 VSS.t13 738.362
R274 VSS.t27 VSS.t29 574.961
R275 VSS.t25 VSS.t3 574.961
R276 VSS.t19 VSS.t21 375.937
R277 VSS.n384 VSS.n48 367.827
R278 VSS.t21 VSS.t17 359.719
R279 VSS.t17 VSS.t11 343.502
R280 VSS.t9 VSS.t10 327.995
R281 VSS.t10 VSS.t0 327.995
R282 VSS.t2 VSS.t30 221.139
R283 VSS.t1 VSS.t2 221.139
R284 VSS.t29 VSS.t1 221.139
R285 VSS.t8 VSS.t4 221.139
R286 VSS.t7 VSS.t8 221.139
R287 VSS.t3 VSS.t7 221.139
R288 VSS.t5 VSS.n392 85.5643
R289 VSS.n136 VSS.t6 25.6392
R290 VSS.n117 VSS.t24 16.6225
R291 VSS.n393 VSS.t5 14.7359
R292 VSS.n248 VSS.t18 12.632
R293 VSS.n63 VSS.t22 7.75329
R294 VSS.n257 VSS.t20 7.75329
R295 VSS.n197 VSS.n196 6.09039
R296 VSS.n472 VSS.n471 5.97354
R297 VSS.n246 VSS.t12 5.22512
R298 VSS.n294 VSS.t28 5.22512
R299 VSS.n1 VSS.t26 5.22512
R300 VSS.n386 VSS.t27 3.68614
R301 VSS.n211 VSS.t16 1.97502
R302 VSS.t14 VSS.n67 1.97502
R303 VSS.n83 VSS.n75 1.83912
R304 VSS.n332 VSS.n331 1.5755
R305 VSS.n317 VSS.n308 1.5755
R306 VSS.n341 VSS.n297 1.5755
R307 VSS.n334 VSS.n299 1.5755
R308 VSS.n363 VSS.n362 1.5755
R309 VSS.n348 VSS.n292 1.5755
R310 VSS.n199 VSS.n198 1.5755
R311 VSS.n370 VSS.n284 1.5755
R312 VSS.n130 VSS.n119 1.5755
R313 VSS.n470 VSS.n469 1.5755
R314 VSS.n146 VSS.n112 1.5755
R315 VSS.n138 VSS.n137 1.5755
R316 VSS.n192 VSS.n90 1.5755
R317 VSS.n153 VSS.n109 1.5755
R318 VSS.n472 VSS.n1 1.52994
R319 VSS.n193 VSS.n192 1.5005
R320 VSS.n191 VSS.n190 1.5005
R321 VSS.n94 VSS.n93 1.5005
R322 VSS.n185 VSS.n184 1.5005
R323 VSS.n183 VSS.n182 1.5005
R324 VSS.n98 VSS.n97 1.5005
R325 VSS.n177 VSS.n176 1.5005
R326 VSS.n175 VSS.n174 1.5005
R327 VSS.n102 VSS.n101 1.5005
R328 VSS.n169 VSS.n168 1.5005
R329 VSS.n167 VSS.n166 1.5005
R330 VSS.n106 VSS.n105 1.5005
R331 VSS.n161 VSS.n160 1.5005
R332 VSS.n159 VSS.n158 1.5005
R333 VSS.n110 VSS.n109 1.5005
R334 VSS.n147 VSS.n146 1.5005
R335 VSS.n145 VSS.n144 1.5005
R336 VSS.n116 VSS.n115 1.5005
R337 VSS.n139 VSS.n138 1.5005
R338 VSS.n131 VSS.n130 1.5005
R339 VSS.n129 VSS.n128 1.5005
R340 VSS.n125 VSS.n123 1.5005
R341 VSS.n41 VSS.n40 1.5005
R342 VSS.n397 VSS.n396 1.5005
R343 VSS.n399 VSS.n398 1.5005
R344 VSS.n37 VSS.n36 1.5005
R345 VSS.n405 VSS.n404 1.5005
R346 VSS.n407 VSS.n406 1.5005
R347 VSS.n33 VSS.n32 1.5005
R348 VSS.n413 VSS.n412 1.5005
R349 VSS.n415 VSS.n414 1.5005
R350 VSS.n29 VSS.n28 1.5005
R351 VSS.n421 VSS.n420 1.5005
R352 VSS.n423 VSS.n422 1.5005
R353 VSS.n25 VSS.n24 1.5005
R354 VSS.n429 VSS.n428 1.5005
R355 VSS.n431 VSS.n430 1.5005
R356 VSS.n21 VSS.n20 1.5005
R357 VSS.n437 VSS.n436 1.5005
R358 VSS.n439 VSS.n438 1.5005
R359 VSS.n17 VSS.n16 1.5005
R360 VSS.n445 VSS.n444 1.5005
R361 VSS.n447 VSS.n446 1.5005
R362 VSS.n13 VSS.n12 1.5005
R363 VSS.n453 VSS.n452 1.5005
R364 VSS.n455 VSS.n454 1.5005
R365 VSS.n9 VSS.n8 1.5005
R366 VSS.n461 VSS.n460 1.5005
R367 VSS.n463 VSS.n462 1.5005
R368 VSS.n5 VSS.n4 1.5005
R369 VSS.n469 VSS.n468 1.5005
R370 VSS.n3 VSS.n2 1.5005
R371 VSS.n467 VSS.n466 1.5005
R372 VSS.n465 VSS.n464 1.5005
R373 VSS.n7 VSS.n6 1.5005
R374 VSS.n459 VSS.n458 1.5005
R375 VSS.n457 VSS.n456 1.5005
R376 VSS.n11 VSS.n10 1.5005
R377 VSS.n451 VSS.n450 1.5005
R378 VSS.n449 VSS.n448 1.5005
R379 VSS.n15 VSS.n14 1.5005
R380 VSS.n443 VSS.n442 1.5005
R381 VSS.n441 VSS.n440 1.5005
R382 VSS.n19 VSS.n18 1.5005
R383 VSS.n435 VSS.n434 1.5005
R384 VSS.n433 VSS.n432 1.5005
R385 VSS.n23 VSS.n22 1.5005
R386 VSS.n427 VSS.n426 1.5005
R387 VSS.n425 VSS.n424 1.5005
R388 VSS.n27 VSS.n26 1.5005
R389 VSS.n419 VSS.n418 1.5005
R390 VSS.n417 VSS.n416 1.5005
R391 VSS.n31 VSS.n30 1.5005
R392 VSS.n411 VSS.n410 1.5005
R393 VSS.n409 VSS.n408 1.5005
R394 VSS.n35 VSS.n34 1.5005
R395 VSS.n403 VSS.n402 1.5005
R396 VSS.n401 VSS.n400 1.5005
R397 VSS.n39 VSS.n38 1.5005
R398 VSS.n395 VSS.n394 1.5005
R399 VSS.n124 VSS.n42 1.5005
R400 VSS.n127 VSS.n126 1.5005
R401 VSS.n122 VSS.n121 1.5005
R402 VSS.n133 VSS.n132 1.5005
R403 VSS.n135 VSS.n134 1.5005
R404 VSS.n120 VSS.n118 1.5005
R405 VSS.n141 VSS.n140 1.5005
R406 VSS.n143 VSS.n142 1.5005
R407 VSS.n114 VSS.n113 1.5005
R408 VSS.n149 VSS.n148 1.5005
R409 VSS.n151 VSS.n150 1.5005
R410 VSS.n152 VSS.n111 1.5005
R411 VSS.n155 VSS.n154 1.5005
R412 VSS.n157 VSS.n156 1.5005
R413 VSS.n108 VSS.n107 1.5005
R414 VSS.n163 VSS.n162 1.5005
R415 VSS.n165 VSS.n164 1.5005
R416 VSS.n104 VSS.n103 1.5005
R417 VSS.n171 VSS.n170 1.5005
R418 VSS.n173 VSS.n172 1.5005
R419 VSS.n100 VSS.n99 1.5005
R420 VSS.n179 VSS.n178 1.5005
R421 VSS.n181 VSS.n180 1.5005
R422 VSS.n96 VSS.n95 1.5005
R423 VSS.n187 VSS.n186 1.5005
R424 VSS.n189 VSS.n188 1.5005
R425 VSS.n92 VSS.n91 1.5005
R426 VSS.n195 VSS.n194 1.5005
R427 VSS.n312 VSS.n0 1.5005
R428 VSS.n313 VSS.n311 1.5005
R429 VSS.n315 VSS.n314 1.5005
R430 VSS.n316 VSS.n310 1.5005
R431 VSS.n319 VSS.n318 1.5005
R432 VSS.n321 VSS.n320 1.5005
R433 VSS.n307 VSS.n306 1.5005
R434 VSS.n327 VSS.n326 1.5005
R435 VSS.n329 VSS.n328 1.5005
R436 VSS.n305 VSS.n302 1.5005
R437 VSS.n333 VSS.n301 1.5005
R438 VSS.n336 VSS.n335 1.5005
R439 VSS.n338 VSS.n337 1.5005
R440 VSS.n298 VSS.n296 1.5005
R441 VSS.n344 VSS.n343 1.5005
R442 VSS.n345 VSS.n295 1.5005
R443 VSS.n347 VSS.n346 1.5005
R444 VSS.n350 VSS.n349 1.5005
R445 VSS.n352 VSS.n351 1.5005
R446 VSS.n291 VSS.n290 1.5005
R447 VSS.n358 VSS.n357 1.5005
R448 VSS.n360 VSS.n359 1.5005
R449 VSS.n289 VSS.n286 1.5005
R450 VSS.n364 VSS.n285 1.5005
R451 VSS.n366 VSS.n365 1.5005
R452 VSS.n368 VSS.n367 1.5005
R453 VSS.n283 VSS.n282 1.5005
R454 VSS.n374 VSS.n373 1.5005
R455 VSS.n376 VSS.n375 1.5005
R456 VSS.n52 VSS.n50 1.5005
R457 VSS.n382 VSS.n381 1.5005
R458 VSS.n276 VSS.n49 1.5005
R459 VSS.n275 VSS.n274 1.5005
R460 VSS.n273 VSS.n272 1.5005
R461 VSS.n56 VSS.n55 1.5005
R462 VSS.n267 VSS.n266 1.5005
R463 VSS.n265 VSS.n264 1.5005
R464 VSS.n60 VSS.n59 1.5005
R465 VSS.n259 VSS.n258 1.5005
R466 VSS.n256 VSS.n255 1.5005
R467 VSS.n247 VSS.n64 1.5005
R468 VSS.n250 VSS.n249 1.5005
R469 VSS.n245 VSS.n244 1.5005
R470 VSS.n237 VSS.n68 1.5005
R471 VSS.n239 VSS.n238 1.5005
R472 VSS.n236 VSS.n235 1.5005
R473 VSS.n72 VSS.n71 1.5005
R474 VSS.n230 VSS.n229 1.5005
R475 VSS.n228 VSS.n227 1.5005
R476 VSS.n220 VSS.n76 1.5005
R477 VSS.n222 VSS.n221 1.5005
R478 VSS.n219 VSS.n218 1.5005
R479 VSS.n80 VSS.n79 1.5005
R480 VSS.n213 VSS.n212 1.5005
R481 VSS.n210 VSS.n209 1.5005
R482 VSS.n85 VSS.n84 1.5005
R483 VSS.n204 VSS.n203 1.5005
R484 VSS.n202 VSS.n201 1.5005
R485 VSS.n89 VSS.n88 1.5005
R486 VSS.n200 VSS.n199 1.5005
R487 VSS.n87 VSS.n86 1.5005
R488 VSS.n206 VSS.n205 1.5005
R489 VSS.n208 VSS.n207 1.5005
R490 VSS.n82 VSS.n81 1.5005
R491 VSS.n215 VSS.n214 1.5005
R492 VSS.n217 VSS.n216 1.5005
R493 VSS.n78 VSS.n77 1.5005
R494 VSS.n224 VSS.n223 1.5005
R495 VSS.n226 VSS.n225 1.5005
R496 VSS.n74 VSS.n73 1.5005
R497 VSS.n232 VSS.n231 1.5005
R498 VSS.n234 VSS.n233 1.5005
R499 VSS.n70 VSS.n69 1.5005
R500 VSS.n241 VSS.n240 1.5005
R501 VSS.n243 VSS.n242 1.5005
R502 VSS.n66 VSS.n65 1.5005
R503 VSS.n252 VSS.n251 1.5005
R504 VSS.n254 VSS.n253 1.5005
R505 VSS.n62 VSS.n61 1.5005
R506 VSS.n261 VSS.n260 1.5005
R507 VSS.n263 VSS.n262 1.5005
R508 VSS.n58 VSS.n57 1.5005
R509 VSS.n269 VSS.n268 1.5005
R510 VSS.n271 VSS.n270 1.5005
R511 VSS.n54 VSS.n53 1.5005
R512 VSS.n278 VSS.n277 1.5005
R513 VSS.n279 VSS.n51 1.5005
R514 VSS.n380 VSS.n379 1.5005
R515 VSS.n378 VSS.n377 1.5005
R516 VSS.n281 VSS.n280 1.5005
R517 VSS.n372 VSS.n371 1.5005
R518 VSS.n370 VSS.n369 1.5005
R519 VSS.n362 VSS.n361 1.5005
R520 VSS.n288 VSS.n287 1.5005
R521 VSS.n356 VSS.n355 1.5005
R522 VSS.n354 VSS.n353 1.5005
R523 VSS.n293 VSS.n292 1.5005
R524 VSS.n342 VSS.n341 1.5005
R525 VSS.n340 VSS.n339 1.5005
R526 VSS.n300 VSS.n299 1.5005
R527 VSS.n331 VSS.n330 1.5005
R528 VSS.n304 VSS.n303 1.5005
R529 VSS.n325 VSS.n324 1.5005
R530 VSS.n323 VSS.n322 1.5005
R531 VSS.n309 VSS.n308 1.5005
R532 VSS.n471 VSS.n2 0.585263
R533 VSS.n196 VSS.n195 0.474495
R534 VSS.n197 VSS.n88 0.474495
R535 VSS.t16 VSS.n83 0.14409
R536 VSS.n83 VSS.t14 0.14409
R537 VSS.n471 VSS.n470 0.117112
R538 VSS.n198 VSS.n197 0.0999609
R539 VSS.n196 VSS.n90 0.0984609
R540 VSS.n331 VSS.n303 0.0755
R541 VSS.n324 VSS.n303 0.0755
R542 VSS.n324 VSS.n323 0.0755
R543 VSS.n323 VSS.n308 0.0755
R544 VSS.n341 VSS.n340 0.0755
R545 VSS.n340 VSS.n299 0.0755
R546 VSS.n362 VSS.n287 0.0755
R547 VSS.n355 VSS.n287 0.0755
R548 VSS.n355 VSS.n354 0.0755
R549 VSS.n354 VSS.n292 0.0755
R550 VSS.n199 VSS.n86 0.0755
R551 VSS.n206 VSS.n86 0.0755
R552 VSS.n207 VSS.n206 0.0755
R553 VSS.n207 VSS.n81 0.0755
R554 VSS.n215 VSS.n81 0.0755
R555 VSS.n216 VSS.n215 0.0755
R556 VSS.n216 VSS.n77 0.0755
R557 VSS.n224 VSS.n77 0.0755
R558 VSS.n225 VSS.n224 0.0755
R559 VSS.n225 VSS.n73 0.0755
R560 VSS.n232 VSS.n73 0.0755
R561 VSS.n233 VSS.n232 0.0755
R562 VSS.n233 VSS.n69 0.0755
R563 VSS.n241 VSS.n69 0.0755
R564 VSS.n242 VSS.n241 0.0755
R565 VSS.n242 VSS.n65 0.0755
R566 VSS.n252 VSS.n65 0.0755
R567 VSS.n253 VSS.n252 0.0755
R568 VSS.n253 VSS.n61 0.0755
R569 VSS.n261 VSS.n61 0.0755
R570 VSS.n262 VSS.n261 0.0755
R571 VSS.n262 VSS.n57 0.0755
R572 VSS.n269 VSS.n57 0.0755
R573 VSS.n270 VSS.n269 0.0755
R574 VSS.n270 VSS.n53 0.0755
R575 VSS.n278 VSS.n53 0.0755
R576 VSS.n279 VSS.n278 0.0755
R577 VSS.n379 VSS.n279 0.0755
R578 VSS.n379 VSS.n378 0.0755
R579 VSS.n378 VSS.n280 0.0755
R580 VSS.n371 VSS.n280 0.0755
R581 VSS.n371 VSS.n370 0.0755
R582 VSS.n130 VSS.n129 0.0755
R583 VSS.n129 VSS.n123 0.0755
R584 VSS.n123 VSS.n40 0.0755
R585 VSS.n397 VSS.n40 0.0755
R586 VSS.n398 VSS.n397 0.0755
R587 VSS.n398 VSS.n36 0.0755
R588 VSS.n405 VSS.n36 0.0755
R589 VSS.n406 VSS.n405 0.0755
R590 VSS.n406 VSS.n32 0.0755
R591 VSS.n413 VSS.n32 0.0755
R592 VSS.n414 VSS.n413 0.0755
R593 VSS.n414 VSS.n28 0.0755
R594 VSS.n421 VSS.n28 0.0755
R595 VSS.n422 VSS.n421 0.0755
R596 VSS.n422 VSS.n24 0.0755
R597 VSS.n429 VSS.n24 0.0755
R598 VSS.n430 VSS.n429 0.0755
R599 VSS.n430 VSS.n20 0.0755
R600 VSS.n437 VSS.n20 0.0755
R601 VSS.n438 VSS.n437 0.0755
R602 VSS.n438 VSS.n16 0.0755
R603 VSS.n445 VSS.n16 0.0755
R604 VSS.n446 VSS.n445 0.0755
R605 VSS.n446 VSS.n12 0.0755
R606 VSS.n453 VSS.n12 0.0755
R607 VSS.n454 VSS.n453 0.0755
R608 VSS.n454 VSS.n8 0.0755
R609 VSS.n461 VSS.n8 0.0755
R610 VSS.n462 VSS.n461 0.0755
R611 VSS.n462 VSS.n4 0.0755
R612 VSS.n469 VSS.n4 0.0755
R613 VSS.n146 VSS.n145 0.0755
R614 VSS.n145 VSS.n115 0.0755
R615 VSS.n138 VSS.n115 0.0755
R616 VSS.n192 VSS.n191 0.0755
R617 VSS.n191 VSS.n93 0.0755
R618 VSS.n184 VSS.n93 0.0755
R619 VSS.n184 VSS.n183 0.0755
R620 VSS.n183 VSS.n97 0.0755
R621 VSS.n176 VSS.n97 0.0755
R622 VSS.n176 VSS.n175 0.0755
R623 VSS.n175 VSS.n101 0.0755
R624 VSS.n168 VSS.n101 0.0755
R625 VSS.n168 VSS.n167 0.0755
R626 VSS.n167 VSS.n105 0.0755
R627 VSS.n160 VSS.n105 0.0755
R628 VSS.n160 VSS.n159 0.0755
R629 VSS.n159 VSS.n109 0.0755
R630 VSS.n152 VSS.n151 0.0755
R631 VSS.n195 VSS.n91 0.0755
R632 VSS.n188 VSS.n91 0.0755
R633 VSS.n188 VSS.n187 0.0755
R634 VSS.n187 VSS.n95 0.0755
R635 VSS.n180 VSS.n95 0.0755
R636 VSS.n180 VSS.n179 0.0755
R637 VSS.n179 VSS.n99 0.0755
R638 VSS.n172 VSS.n99 0.0755
R639 VSS.n172 VSS.n171 0.0755
R640 VSS.n171 VSS.n103 0.0755
R641 VSS.n164 VSS.n103 0.0755
R642 VSS.n164 VSS.n163 0.0755
R643 VSS.n163 VSS.n107 0.0755
R644 VSS.n156 VSS.n107 0.0755
R645 VSS.n156 VSS.n155 0.0755
R646 VSS.n155 VSS.n111 0.0755
R647 VSS.n150 VSS.n111 0.0755
R648 VSS.n150 VSS.n149 0.0755
R649 VSS.n149 VSS.n113 0.0755
R650 VSS.n142 VSS.n113 0.0755
R651 VSS.n142 VSS.n141 0.0755
R652 VSS.n134 VSS.n120 0.0755
R653 VSS.n134 VSS.n133 0.0755
R654 VSS.n133 VSS.n121 0.0755
R655 VSS.n126 VSS.n121 0.0755
R656 VSS.n126 VSS.n42 0.0755
R657 VSS.n394 VSS.n38 0.0755
R658 VSS.n401 VSS.n38 0.0755
R659 VSS.n402 VSS.n401 0.0755
R660 VSS.n402 VSS.n34 0.0755
R661 VSS.n409 VSS.n34 0.0755
R662 VSS.n410 VSS.n409 0.0755
R663 VSS.n410 VSS.n30 0.0755
R664 VSS.n417 VSS.n30 0.0755
R665 VSS.n418 VSS.n417 0.0755
R666 VSS.n418 VSS.n26 0.0755
R667 VSS.n425 VSS.n26 0.0755
R668 VSS.n426 VSS.n425 0.0755
R669 VSS.n426 VSS.n22 0.0755
R670 VSS.n433 VSS.n22 0.0755
R671 VSS.n434 VSS.n433 0.0755
R672 VSS.n434 VSS.n18 0.0755
R673 VSS.n441 VSS.n18 0.0755
R674 VSS.n442 VSS.n441 0.0755
R675 VSS.n442 VSS.n14 0.0755
R676 VSS.n449 VSS.n14 0.0755
R677 VSS.n450 VSS.n449 0.0755
R678 VSS.n450 VSS.n10 0.0755
R679 VSS.n457 VSS.n10 0.0755
R680 VSS.n458 VSS.n457 0.0755
R681 VSS.n458 VSS.n6 0.0755
R682 VSS.n465 VSS.n6 0.0755
R683 VSS.n466 VSS.n465 0.0755
R684 VSS.n466 VSS.n2 0.0755
R685 VSS.n202 VSS.n88 0.0755
R686 VSS.n203 VSS.n202 0.0755
R687 VSS.n203 VSS.n84 0.0755
R688 VSS.n210 VSS.n84 0.0755
R689 VSS.n212 VSS.n79 0.0755
R690 VSS.n219 VSS.n79 0.0755
R691 VSS.n221 VSS.n219 0.0755
R692 VSS.n221 VSS.n220 0.0755
R693 VSS.n229 VSS.n228 0.0755
R694 VSS.n229 VSS.n71 0.0755
R695 VSS.n236 VSS.n71 0.0755
R696 VSS.n238 VSS.n236 0.0755
R697 VSS.n238 VSS.n237 0.0755
R698 VSS.n258 VSS.n256 0.0755
R699 VSS.n265 VSS.n59 0.0755
R700 VSS.n266 VSS.n265 0.0755
R701 VSS.n266 VSS.n55 0.0755
R702 VSS.n273 VSS.n55 0.0755
R703 VSS.n274 VSS.n273 0.0755
R704 VSS.n274 VSS.n49 0.0755
R705 VSS.n382 VSS.n50 0.0755
R706 VSS.n375 VSS.n50 0.0755
R707 VSS.n375 VSS.n374 0.0755
R708 VSS.n374 VSS.n282 0.0755
R709 VSS.n367 VSS.n282 0.0755
R710 VSS.n367 VSS.n366 0.0755
R711 VSS.n366 VSS.n285 0.0755
R712 VSS.n289 VSS.n285 0.0755
R713 VSS.n359 VSS.n289 0.0755
R714 VSS.n359 VSS.n358 0.0755
R715 VSS.n358 VSS.n290 0.0755
R716 VSS.n351 VSS.n290 0.0755
R717 VSS.n351 VSS.n350 0.0755
R718 VSS.n346 VSS.n345 0.0755
R719 VSS.n345 VSS.n344 0.0755
R720 VSS.n344 VSS.n296 0.0755
R721 VSS.n337 VSS.n296 0.0755
R722 VSS.n337 VSS.n336 0.0755
R723 VSS.n336 VSS.n301 0.0755
R724 VSS.n305 VSS.n301 0.0755
R725 VSS.n328 VSS.n305 0.0755
R726 VSS.n328 VSS.n327 0.0755
R727 VSS.n327 VSS.n306 0.0755
R728 VSS.n320 VSS.n306 0.0755
R729 VSS.n320 VSS.n319 0.0755
R730 VSS.n319 VSS.n310 0.0755
R731 VSS.n314 VSS.n310 0.0755
R732 VSS.n314 VSS.n313 0.0755
R733 VSS.n313 VSS.n312 0.0755
R734 VSS.n365 VSS.n364 0.0755
R735 VSS.n347 VSS.n295 0.0755
R736 VSS.n316 VSS.n315 0.0755
R737 VSS.n315 VSS.n311 0.0755
R738 VSS.n311 VSS.n0 0.0755
R739 VSS.n148 VSS.n112 0.0749375
R740 VSS.n147 VSS.n114 0.0749375
R741 VSS.n144 VSS.n143 0.0749375
R742 VSS.n140 VSS.n116 0.0749375
R743 VSS.n139 VSS.n118 0.0749375
R744 VSS.n257 VSS.n59 0.0730625
R745 VSS.n343 VSS.n297 0.0725
R746 VSS.n342 VSS.n298 0.0725
R747 VSS.n339 VSS.n338 0.0725
R748 VSS.n335 VSS.n300 0.0725
R749 VSS.n334 VSS.n333 0.0725
R750 VSS.n194 VSS.n90 0.0695
R751 VSS.n193 VSS.n92 0.0695
R752 VSS.n190 VSS.n189 0.0695
R753 VSS.n186 VSS.n94 0.0695
R754 VSS.n185 VSS.n96 0.0695
R755 VSS.n182 VSS.n181 0.0695
R756 VSS.n178 VSS.n98 0.0695
R757 VSS.n177 VSS.n100 0.0695
R758 VSS.n174 VSS.n173 0.0695
R759 VSS.n170 VSS.n102 0.0695
R760 VSS.n169 VSS.n104 0.0695
R761 VSS.n166 VSS.n165 0.0695
R762 VSS.n162 VSS.n106 0.0695
R763 VSS.n161 VSS.n108 0.0695
R764 VSS.n158 VSS.n157 0.0695
R765 VSS.n154 VSS.n110 0.0695
R766 VSS.n153 VSS.n152 0.0695
R767 VSS.n141 VSS.n117 0.0695
R768 VSS.n198 VSS.n89 0.068
R769 VSS.n201 VSS.n200 0.068
R770 VSS.n204 VSS.n87 0.068
R771 VSS.n205 VSS.n85 0.068
R772 VSS.n209 VSS.n208 0.068
R773 VSS.n213 VSS.n82 0.068
R774 VSS.n214 VSS.n80 0.068
R775 VSS.n218 VSS.n217 0.068
R776 VSS.n222 VSS.n78 0.068
R777 VSS.n223 VSS.n76 0.068
R778 VSS.n227 VSS.n226 0.068
R779 VSS.n230 VSS.n74 0.068
R780 VSS.n231 VSS.n72 0.068
R781 VSS.n235 VSS.n234 0.068
R782 VSS.n239 VSS.n70 0.068
R783 VSS.n240 VSS.n68 0.068
R784 VSS.n244 VSS.n243 0.068
R785 VSS.n250 VSS.n66 0.068
R786 VSS.n251 VSS.n64 0.068
R787 VSS.n255 VSS.n254 0.068
R788 VSS.n259 VSS.n62 0.068
R789 VSS.n260 VSS.n60 0.068
R790 VSS.n264 VSS.n263 0.068
R791 VSS.n267 VSS.n58 0.068
R792 VSS.n268 VSS.n56 0.068
R793 VSS.n272 VSS.n271 0.068
R794 VSS.n275 VSS.n54 0.068
R795 VSS.n277 VSS.n276 0.068
R796 VSS.n381 VSS.n51 0.068
R797 VSS.n380 VSS.n52 0.068
R798 VSS.n377 VSS.n376 0.068
R799 VSS.n373 VSS.n281 0.068
R800 VSS.n372 VSS.n283 0.068
R801 VSS.n369 VSS.n368 0.068
R802 VSS.n365 VSS.n284 0.068
R803 VSS.n220 VSS.n75 0.0665
R804 VSS.n333 VSS.n332 0.065
R805 VSS.n330 VSS.n302 0.065
R806 VSS.n329 VSS.n304 0.065
R807 VSS.n326 VSS.n325 0.065
R808 VSS.n322 VSS.n307 0.065
R809 VSS.n321 VSS.n309 0.065
R810 VSS.n318 VSS.n317 0.065
R811 VSS.n245 VSS.n67 0.0640625
R812 VSS.n350 VSS.n294 0.0614375
R813 VSS.n247 VSS.n63 0.0573125
R814 VSS.n394 VSS.n393 0.056
R815 VSS.n383 VSS.n382 0.056
R816 VSS.n363 VSS.n286 0.056
R817 VSS.n361 VSS.n360 0.056
R818 VSS.n357 VSS.n288 0.056
R819 VSS.n356 VSS.n291 0.056
R820 VSS.n353 VSS.n352 0.056
R821 VSS.n349 VSS.n293 0.056
R822 VSS.n348 VSS.n347 0.056
R823 VSS VSS.n0 0.054875
R824 VSS.n249 VSS.n246 0.0516875
R825 VSS.n312 VSS.n1 0.0498125
R826 VSS.n132 VSS.n119 0.04925
R827 VSS.n131 VSS.n122 0.04925
R828 VSS.n128 VSS.n127 0.04925
R829 VSS.n125 VSS.n124 0.04925
R830 VSS.n395 VSS.n41 0.04925
R831 VSS.n396 VSS.n39 0.04925
R832 VSS.n400 VSS.n399 0.04925
R833 VSS.n403 VSS.n37 0.04925
R834 VSS.n404 VSS.n35 0.04925
R835 VSS.n408 VSS.n407 0.04925
R836 VSS.n411 VSS.n33 0.04925
R837 VSS.n412 VSS.n31 0.04925
R838 VSS.n416 VSS.n415 0.04925
R839 VSS.n419 VSS.n29 0.04925
R840 VSS.n420 VSS.n27 0.04925
R841 VSS.n424 VSS.n423 0.04925
R842 VSS.n427 VSS.n25 0.04925
R843 VSS.n428 VSS.n23 0.04925
R844 VSS.n432 VSS.n431 0.04925
R845 VSS.n435 VSS.n21 0.04925
R846 VSS.n436 VSS.n19 0.04925
R847 VSS.n440 VSS.n439 0.04925
R848 VSS.n443 VSS.n17 0.04925
R849 VSS.n444 VSS.n15 0.04925
R850 VSS.n448 VSS.n447 0.04925
R851 VSS.n451 VSS.n13 0.04925
R852 VSS.n452 VSS.n11 0.04925
R853 VSS.n456 VSS.n455 0.04925
R854 VSS.n459 VSS.n9 0.04925
R855 VSS.n460 VSS.n7 0.04925
R856 VSS.n464 VSS.n463 0.04925
R857 VSS.n467 VSS.n5 0.04925
R858 VSS.n468 VSS.n3 0.04925
R859 VSS.n211 VSS.n210 0.0460625
R860 VSS.n137 VSS.n136 0.0455
R861 VSS.n248 VSS.n247 0.0393125
R862 VSS.n384 VSS.n383 0.0390185
R863 VSS.n249 VSS.n248 0.0366875
R864 VSS.n136 VSS.n135 0.0299375
R865 VSS.n212 VSS.n211 0.0299375
R866 VSS.n135 VSS.n119 0.02675
R867 VSS.n132 VSS.n131 0.02675
R868 VSS.n128 VSS.n122 0.02675
R869 VSS.n127 VSS.n125 0.02675
R870 VSS.n124 VSS.n41 0.02675
R871 VSS.n396 VSS.n395 0.02675
R872 VSS.n399 VSS.n39 0.02675
R873 VSS.n400 VSS.n37 0.02675
R874 VSS.n404 VSS.n403 0.02675
R875 VSS.n407 VSS.n35 0.02675
R876 VSS.n408 VSS.n33 0.02675
R877 VSS.n412 VSS.n411 0.02675
R878 VSS.n415 VSS.n31 0.02675
R879 VSS.n416 VSS.n29 0.02675
R880 VSS.n420 VSS.n419 0.02675
R881 VSS.n423 VSS.n27 0.02675
R882 VSS.n424 VSS.n25 0.02675
R883 VSS.n428 VSS.n427 0.02675
R884 VSS.n431 VSS.n23 0.02675
R885 VSS.n432 VSS.n21 0.02675
R886 VSS.n436 VSS.n435 0.02675
R887 VSS.n439 VSS.n19 0.02675
R888 VSS.n440 VSS.n17 0.02675
R889 VSS.n444 VSS.n443 0.02675
R890 VSS.n447 VSS.n15 0.02675
R891 VSS.n448 VSS.n13 0.02675
R892 VSS.n452 VSS.n451 0.02675
R893 VSS.n455 VSS.n11 0.02675
R894 VSS.n456 VSS.n9 0.02675
R895 VSS.n460 VSS.n459 0.02675
R896 VSS.n463 VSS.n7 0.02675
R897 VSS.n464 VSS.n5 0.02675
R898 VSS.n468 VSS.n467 0.02675
R899 VSS.n470 VSS.n3 0.02675
R900 VSS.n246 VSS.n245 0.0243125
R901 VSS.n393 VSS.n42 0.02
R902 VSS.n383 VSS.n49 0.02
R903 VSS.n364 VSS.n363 0.02
R904 VSS.n361 VSS.n286 0.02
R905 VSS.n360 VSS.n288 0.02
R906 VSS.n357 VSS.n356 0.02
R907 VSS.n353 VSS.n291 0.02
R908 VSS.n352 VSS.n293 0.02
R909 VSS.n349 VSS.n348 0.02
R910 VSS.n256 VSS.n63 0.0186875
R911 VSS VSS.n472 0.017375
R912 VSS.n346 VSS.n294 0.0145625
R913 VSS.n237 VSS.n67 0.0119375
R914 VSS.n332 VSS.n302 0.011
R915 VSS.n330 VSS.n329 0.011
R916 VSS.n326 VSS.n304 0.011
R917 VSS.n325 VSS.n307 0.011
R918 VSS.n322 VSS.n321 0.011
R919 VSS.n318 VSS.n309 0.011
R920 VSS.n317 VSS.n316 0.011
R921 VSS.n228 VSS.n75 0.0095
R922 VSS.n200 VSS.n89 0.008
R923 VSS.n201 VSS.n87 0.008
R924 VSS.n205 VSS.n204 0.008
R925 VSS.n208 VSS.n85 0.008
R926 VSS.n209 VSS.n82 0.008
R927 VSS.n214 VSS.n213 0.008
R928 VSS.n217 VSS.n80 0.008
R929 VSS.n218 VSS.n78 0.008
R930 VSS.n223 VSS.n222 0.008
R931 VSS.n226 VSS.n76 0.008
R932 VSS.n227 VSS.n74 0.008
R933 VSS.n231 VSS.n230 0.008
R934 VSS.n234 VSS.n72 0.008
R935 VSS.n235 VSS.n70 0.008
R936 VSS.n240 VSS.n239 0.008
R937 VSS.n243 VSS.n68 0.008
R938 VSS.n244 VSS.n66 0.008
R939 VSS.n251 VSS.n250 0.008
R940 VSS.n254 VSS.n64 0.008
R941 VSS.n255 VSS.n62 0.008
R942 VSS.n260 VSS.n259 0.008
R943 VSS.n263 VSS.n60 0.008
R944 VSS.n264 VSS.n58 0.008
R945 VSS.n268 VSS.n267 0.008
R946 VSS.n271 VSS.n56 0.008
R947 VSS.n272 VSS.n54 0.008
R948 VSS.n277 VSS.n275 0.008
R949 VSS.n276 VSS.n51 0.008
R950 VSS.n381 VSS.n380 0.008
R951 VSS.n377 VSS.n52 0.008
R952 VSS.n376 VSS.n281 0.008
R953 VSS.n373 VSS.n372 0.008
R954 VSS.n369 VSS.n283 0.008
R955 VSS.n368 VSS.n284 0.008
R956 VSS.n194 VSS.n193 0.0065
R957 VSS.n190 VSS.n92 0.0065
R958 VSS.n189 VSS.n94 0.0065
R959 VSS.n186 VSS.n185 0.0065
R960 VSS.n182 VSS.n96 0.0065
R961 VSS.n181 VSS.n98 0.0065
R962 VSS.n178 VSS.n177 0.0065
R963 VSS.n174 VSS.n100 0.0065
R964 VSS.n173 VSS.n102 0.0065
R965 VSS.n170 VSS.n169 0.0065
R966 VSS.n166 VSS.n104 0.0065
R967 VSS.n165 VSS.n106 0.0065
R968 VSS.n162 VSS.n161 0.0065
R969 VSS.n158 VSS.n108 0.0065
R970 VSS.n157 VSS.n110 0.0065
R971 VSS.n154 VSS.n153 0.0065
R972 VSS.n120 VSS.n117 0.0065
R973 VSS.n297 VSS.n295 0.0035
R974 VSS.n343 VSS.n342 0.0035
R975 VSS.n339 VSS.n298 0.0035
R976 VSS.n338 VSS.n300 0.0035
R977 VSS.n335 VSS.n334 0.0035
R978 VSS.n258 VSS.n257 0.0029375
R979 VSS.n151 VSS.n112 0.0010625
R980 VSS.n148 VSS.n147 0.0010625
R981 VSS.n144 VSS.n114 0.0010625
R982 VSS.n143 VSS.n116 0.0010625
R983 VSS.n140 VSS.n139 0.0010625
R984 VSS.n137 VSS.n118 0.0010625
C0 cb nb 0.10392f
C1 nb mRpLb 0.09398f
C2 co gcn 0.00689f
C3 vgr mRpCb 0.03293f
C4 vgr glp 0.11821f
C5 inn ln 0.93324f
C6 gcn cq 0
C7 vb cq 0.00355f
C8 gcp lp 2.0507f
C9 glp inp 2.16317f
C10 ca ct 0.33596f
C11 tL glp 0.64021f
C12 VDD mRpCb 0.13847f
C13 glp enb 0.00176f
C14 vgr gcn 3.17454f
C15 co q 0.02598f
C16 VDD glp 1.20093f
C17 co ca 0.34422f
C18 cb ct 0.22508f
C19 vgr vb 9.55397f
C20 vgr vbt 0.76002f
C21 q cq 1.44037f
C22 ca cq 0
C23 gcp nb 0.94136f
C24 co cb 0
C25 vgr mRpCa 0.15699f
C26 cb cq 0
C27 lp nb 0.15624f
C28 enb gcn 0.00488f
C29 glp mRpLa 2.72864f
C30 glp ln 2.62696f
C31 vbt inp 0.42476f
C32 VDD gcn 1.72094f
C33 cx gcn 0.01262f
C34 vbt enb 0.99337f
C35 vgr q 0.11145f
C36 VDD vb 5.42021f
C37 VDD vbt 0.67806f
C38 gln vgr 2.26794f
C39 VDD mRpCa 0.16896f
C40 vgr mRpLb 1.38037f
C41 gcn ln 4.21834f
C42 inn glp 0.1613f
C43 vb ln 0.22387f
C44 vb mRpLa 1.00198f
C45 vbt ln 0.88479f
C46 vbt mRpLa 0.07167f
C47 gcp ct 0.95309f
C48 gln inp 0.30002f
C49 ca enb 0.00985f
C50 VDD q 1.28715f
C51 cx q 0.00495f
C52 gln tL 0.66214f
C53 VDD ca 0.90731f
C54 gln enb 0.01156f
C55 cx ca 0.19538f
C56 lp ct 0.00147f
C57 gln VDD 1.67514f
C58 cb enb 0.00333f
C59 VDD cb 1.09254f
C60 cx cb 0.17701f
C61 VDD mRpLb 0.03387f
C62 ca ln 0.33477f
C63 gln ln 0.99875f
C64 gln mRpLa 0.14083f
C65 cb ln 0.24663f
C66 nb ct 0.94367f
C67 gcp vgr 3.10457f
C68 mRpLb mRpLa 0.08841f
C69 vgr lp 0.12743f
C70 gln inn 2.16225f
C71 gcp enb 0.00536f
C72 mRpCb gcn 0.54081f
C73 lp inp 0.15192f
C74 gcp VDD 1.6543f
C75 gcp cx 0
C76 tL lp 0.40988f
C77 enb lp 0.05f
C78 mRpCb vb 0.39812f
C79 VDD lp 1.6706f
C80 glp vb 3.18848f
C81 vgr nb 0.35015f
C82 vbt glp 0.87545f
C83 mRpCa mRpCb 0.76885f
C84 gcp ln 2.31969f
C85 nb inp 1.14371f
C86 lp ln 0.86658f
C87 tL nb 0.95043f
C88 vb gcn 2.44488f
C89 enb nb 0.27802f
C90 vbt gcn 0
C91 VDD nb 0.90412f
C92 co cq 1.35725f
C93 vbt vb 0.94378f
C94 gln glp 0.84592f
C95 mRpCa gcn 0.26877f
C96 glp mRpLb 0.10842f
C97 mRpCa vb 0.98733f
C98 nb ln 0.42806f
C99 inn lp 0.18927f
C100 gcn q 0.0493f
C101 nb mRpLa 0.13287f
C102 ca gcn 3.24031f
C103 vb q 0.24451f
C104 gln gcn 0
C105 vbt ca 0.02106f
C106 cb gcn 1.53463f
C107 gln vb 2.65772f
C108 gln vbt 0.37516f
C109 enb ct 0.05233f
C110 mRpCa q 0.062f
C111 cb vbt 0.00161f
C112 vb mRpLb 0.73361f
C113 inn nb 0.24657f
C114 VDD co 0.40432f
C115 co cx 0.28525f
C116 gcp mRpCb 0.14475f
C117 ca q 0.0045f
C118 VDD cq 0.3678f
C119 cx cq 0
C120 gcp glp 0
C121 ln ct 0.12331f
C122 cb q 0
C123 cb ca 1.75008f
C124 glp lp 0.74628f
C125 gln mRpLb 0.60267f
C126 VDD vgr 1.92891f
C127 gcp gcn 1.16018f
C128 gcp vb 0.47644f
C129 lp gcn 0.00459f
C130 mRpCb nb 0.01135f
C131 tL inp 0.00244f
C132 gcp vbt 0.00317f
C133 enb inp 0.07273f
C134 glp nb 0.15007f
C135 VDD inp 0.5372f
C136 vb lp 0.23236f
C137 vbt lp 0.14942f
C138 tL VDD 0.15191f
C139 vgr ln 2.69553f
C140 vgr mRpLa 0.15699f
C141 gcp mRpCa 0.45829f
C142 VDD enb 0.1277f
C143 VDD cx 0.26162f
C144 gcp q 0.05927f
C145 gcp ca 1.11631f
C146 ln inp 0.48261f
C147 nb gcn 0.46544f
C148 tL ln 0.51422f
C149 gcp gln 0
C150 enb ln 0.10666f
C151 ca lp 0.95018f
C152 vb nb 4.64825f
C153 gcp cb 0.40553f
C154 VDD ln 1.61607f
C155 VDD mRpLa 0.21658f
C156 vbt nb 0.12882f
C157 gln lp 4.11236f
C158 inn vgr 0
C159 cb lp 0.8057f
C160 mRpCa nb 1.82097f
C161 inn inp 0.31251f
C162 ln mRpLa 0.05545f
C163 inn tL 0.77929f
C164 nb q 0.11424f
C165 ca nb 0.15947f
C166 inn VDD 0.93785f
C167 gln nb 0.20704f
C168 gcn ct 0.61274f
C169 q VSS 2.4975f
C170 enb VSS 1.73283f
C171 nb VSS 11.1246f
C172 inp VSS 19.693f
C173 inn VSS 20.0415f
C174 VDD VSS 80.7404f
C175 ct VSS 0.51595f
C176 tL VSS 0.58458f
C177 co VSS 0.91906f
C178 cx VSS 1.19827f
C179 ca VSS 2.01225f
C180 cb VSS 1.40544f
C181 cq VSS 0.83872f
C182 mRpCb VSS 0.7771f
C183 mRpCa VSS 0.84957f
C184 mRpLb VSS 1.72501f
C185 mRpLa VSS 0.89621f
C186 vgr VSS 8.62087f
C187 vbt VSS 1.12351f
C188 ln VSS 26.3714f
C189 lp VSS 23.7524f
C190 gcn VSS 4.97705f
C191 gcp VSS 6.82732f
C192 gln VSS 4.45896f
C193 glp VSS 4.34318f
C194 vb VSS 66.6394f
C195 VDD.n0 VSS 0.384297f
C196 VDD.n1 VSS 0.05574f
C197 VDD.n2 VSS 0.10405f
C198 VDD.n3 VSS 0.0520288f
C199 VDD.n4 VSS 0.269538f
C200 VDD.n5 VSS 0.0520288f
C201 VDD.n6 VSS 0.10405f
C202 VDD.n7 VSS 0.065014f
C203 VDD.n8 VSS 0.104082f
C204 VDD.n9 VSS 0.10405f
C205 VDD.t5 VSS 0.0321663f
C206 VDD.n10 VSS 0.10405f
C207 VDD.n11 VSS 0.0520288f
C208 VDD.n12 VSS 0.10405f
C209 VDD.n13 VSS 0.0520288f
C210 VDD.n14 VSS 0.10405f
C211 VDD.n15 VSS 0.0520288f
C212 VDD.n16 VSS 0.10405f
C213 VDD.n17 VSS 0.0520288f
C214 VDD.n18 VSS 0.10405f
C215 VDD.n19 VSS 0.0520288f
C216 VDD.n20 VSS 0.05574f
C217 VDD.n21 VSS 0.10405f
C218 VDD.n22 VSS 0.0520288f
C219 VDD.n23 VSS 0.10405f
C220 VDD.n24 VSS 0.0520288f
C221 VDD.n25 VSS 0.10405f
C222 VDD.n26 VSS 0.0520288f
C223 VDD.n27 VSS 0.10405f
C224 VDD.n28 VSS 0.0520288f
C225 VDD.n29 VSS 0.0919542f
C226 VDD.n30 VSS 0.0520288f
C227 VDD.n31 VSS 0.0574233f
C228 VDD.t15 VSS 0.0454561f
C229 VDD.n32 VSS 0.135919f
C230 VDD.n33 VSS 0.0426987f
C231 VDD.t13 VSS 0.0454561f
C232 VDD.t19 VSS 0.0321663f
C233 VDD.t17 VSS 0.0518284f
C234 VDD.n34 VSS 0.132481f
C235 VDD.n35 VSS 0.0520288f
C236 VDD.n36 VSS 0.10405f
C237 VDD.n37 VSS 0.0520288f
C238 VDD.t9 VSS 0.0518284f
C239 VDD.t7 VSS 0.0358294f
C240 VDD.n38 VSS 0.141153f
C241 VDD.n39 VSS 0.0520288f
C242 VDD.t3 VSS 0.0950802f
C243 VDD.n40 VSS 0.0606134f
C244 VDD.n41 VSS 1.76153f
C245 VDD.n42 VSS 1.81258f
C246 VDD.n43 VSS 0.20216f
C247 VDD.n44 VSS 0.0520288f
C248 VDD.n45 VSS 0.0520288f
C249 VDD.n46 VSS 0.0663285f
C250 VDD.n47 VSS 0.132481f
C251 VDD.n48 VSS 0.0537201f
C252 VDD.n49 VSS 0.0646453f
C253 VDD.n50 VSS 0.0520288f
C254 VDD.n51 VSS 0.0520288f
C255 VDD.n52 VSS 0.17837f
C256 VDD.n53 VSS 0.05574f
C257 VDD.n54 VSS 0.0769972f
C258 VDD.n55 VSS 0.0715386f
C259 VDD.n56 VSS 0.142388f
C260 VDD.n57 VSS 0.0663285f
C261 VDD.n58 VSS 0.135919f
C262 VDD.n59 VSS 0.0663285f
C263 VDD.n60 VSS 0.0259703f
C264 VDD.n61 VSS 0.0572309f
C265 VDD.n62 VSS 0.0542331f
C266 VDD.t11 VSS 0.0321663f
C267 VDD.n63 VSS 0.142388f
C268 VDD.n64 VSS 0.0641242f
C269 VDD.n65 VSS 0.0520288f
C270 VDD.n66 VSS 0.0520288f
C271 VDD.n67 VSS 0.212067f
C272 VDD.n68 VSS 0.10405f
C273 VDD.n69 VSS 0.0520288f
C274 VDD.n70 VSS 0.0520288f
C275 VDD.n71 VSS 0.065551f
C276 VDD.t2 VSS -0.190024f
C277 VDD.t6 VSS 0.83315f
C278 VDD.t8 VSS 0.871577f
C279 VDD.t16 VSS 0.925722f
C280 VDD.t18 VSS 0.925722f
C281 VDD.t12 VSS 0.89079f
C282 VDD.t14 VSS 0.89079f
C283 VDD.t10 VSS 0.939901f
C284 VDD.t4 VSS 0.52109f
C285 VDD.n72 VSS -0.0176582f
C286 VDD.n73 VSS -0.471706f
C287 VDD.n74 VSS 0.0905274f
C288 VDD.n75 VSS 0.0520288f
C289 VDD.n76 VSS 0.0520288f
C290 VDD.n77 VSS 0.10405f
C291 VDD.n78 VSS 0.10405f
C292 VDD.n79 VSS 0.0520288f
C293 VDD.n80 VSS 0.0520288f
C294 VDD.n81 VSS 0.10405f
C295 VDD.n82 VSS 0.10405f
C296 VDD.n83 VSS 0.0520288f
C297 VDD.n84 VSS 0.0520288f
C298 VDD.n85 VSS 0.10405f
C299 VDD.n86 VSS 0.17837f
C300 VDD.n87 VSS 0.0520288f
C301 VDD.n88 VSS 0.0520288f
C302 VDD.n89 VSS 0.10405f
C303 VDD.n90 VSS 0.10405f
C304 VDD.n91 VSS 0.0957295f
C305 VDD.n92 VSS 0.0589141f
C306 VDD.n93 VSS 0.241796f
C307 VDD.n94 VSS 0.0520288f
C308 VDD.n95 VSS 0.0520288f
C309 VDD.n96 VSS 0.10405f
C310 VDD.n97 VSS 0.10405f
C311 VDD.n98 VSS 0.0520288f
C312 VDD.n99 VSS 0.0520288f
C313 VDD.n100 VSS 0.10405f
C314 VDD.n101 VSS 0.10405f
C315 VDD.n102 VSS 0.0520288f
C316 VDD.n103 VSS 0.0520288f
C317 VDD.n104 VSS 0.10405f
C318 VDD.n105 VSS 0.10405f
C319 VDD.n106 VSS 0.0520288f
C320 VDD.n107 VSS 0.0520288f
C321 VDD.n108 VSS 0.17837f
C322 VDD.n109 VSS 0.05574f
C323 VDD.n110 VSS 0.0551469f
C324 VDD.n111 VSS 0.10405f
C325 VDD.n112 VSS 0.0560606f
C326 VDD.n113 VSS 0.142388f
C327 VDD.n114 VSS 0.100018f
C328 VDD.n115 VSS 0.137787f
C329 VDD.n116 VSS 0.209935f
C330 VDD.n117 VSS 0.174586f
C331 VDD.n118 VSS 0.10405f
C332 VDD.n119 VSS 0.10405f
C333 VDD.n120 VSS 0.10405f
C334 VDD.n121 VSS 0.0036631f
C335 VDD.n122 VSS 0.0957295f
C336 VDD.n123 VSS 0.0603008f
C337 VDD.n124 VSS 0.0520288f
C338 VDD.n125 VSS 0.10405f
C339 VDD.n126 VSS 0.10405f
C340 VDD.n127 VSS 0.0520288f
C341 VDD.n128 VSS 0.0520288f
C342 VDD.n129 VSS 0.10405f
C343 VDD.n130 VSS 0.17837f
C344 VDD.n131 VSS 0.0520288f
C345 VDD.n132 VSS 0.0520288f
C346 VDD.n133 VSS 0.10405f
C347 VDD.n134 VSS 0.10405f
C348 VDD.n135 VSS 0.0603489f
C349 VDD.n136 VSS 0.0781675f
C350 VDD.t1 VSS 0.0403903f
C351 VDD.t0 VSS 0.0312766f
C352 VDD.n137 VSS 0.164791f
C353 VDD.n138 VSS -0.669465f
C354 VDD.n139 VSS -0.848524f
C355 inn.t1 VSS 0.690223f
C356 inn.t0 VSS 2.59357f
C357 inn.n0 VSS 1.13404f
C358 inn.n1 VSS 0.100641f
C359 inp.t1 VSS 0.68057f
C360 inp.t0 VSS 2.53119f
C361 inp.n0 VSS 1.11264f
C362 inp.n1 VSS 0.0976255f
C363 nb.t2 VSS 3.25059f
C364 nb.t1 VSS 0.133881f
C365 nb.t0 VSS 0.0735449f
C366 nb.n0 VSS 0.528607f
C367 nb.n1 VSS 1.13404f
C368 enb.t0 VSS 0.0496647f
C369 q.t0 VSS 0.309348f
C370 q.t1 VSS 0.0801364f
C371 q.n0 VSS 0.583106f
.ends
